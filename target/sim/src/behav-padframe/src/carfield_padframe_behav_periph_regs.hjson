

{
    # File auto-generated by Padrick unknown
    name: "carfield_padframe_behav_periph_config"
    clock_primary: "clk_i"
    reset_primary: "rst_ni"
    bus_interfaces: [
        { protocol: "reg_iface", direction: "device"}
    ]
    regwidth: 32,
    registers: [
        {skipto: "0x0"},
        {
            name: INFO
            desc: "Read-only IP Information register"
            swaccess: "ro"
            hwaccess: "hro"
            fields: [
              {
                bits: "15:0"
                name: HW_VERSION
                desc: "Hardware version ID."
                resval: 2
              },
              {
                  bits:"31:16"
                  name: PADCOUNT
                  desc: "The number of muxable pads in this IP."
                  resval: "62"
              }
            ]
        }













      {
          name: HOST_00_CFG
          desc: '''
            Pad signal configuration.
          '''
          swaccess: "rw"
          fields: [
            {
                bits: "0"
                name: chip2pad
                desc: '''
                     Data input pin from core
                '''
                swaccess: "rw"
                hwaccess: "hro"
                resval: "0"
            },
            {
                bits: "1"
                name: drv0
                desc: '''
                     Drive strength configuration bit 0 (LSB) 
                '''
                swaccess: "rw"
                hwaccess: "hro"
                resval: "1"
            },
            {
                bits: "2"
                name: drv1
                desc: '''
                     Drive strength configuration bit 1 
                '''
                swaccess: "rw"
                hwaccess: "hro"
                resval: "1"
            },
            {
                bits: "3"
                name: drv2
                desc: '''
                     Drive strength configuration bit 2 (MSB) 
                '''
                swaccess: "rw"
                hwaccess: "hro"
                resval: "1"
            },
            {
                bits: "4"
                name: pde
                desc: '''
                     active high weak pull-down enable
                '''
                swaccess: "rw"
                hwaccess: "hro"
                resval: "0"
            },
            {
                bits: "5"
                name: pp_odrain_selector
                desc: '''
                      Push-pull /Open Drain select pin 
                '''
                swaccess: "rw"
                hwaccess: "hro"
                resval: "1"
            },
            {
                bits: "6"
                name: pudis
                desc: '''
                     Active high disable weak pull-up
                '''
                swaccess: "rw"
                hwaccess: "hro"
                resval: "1"
            },
            {
                bits: "7"
                name: rxdis
                desc: '''
                     active high Disable receiver
                '''
                swaccess: "rw"
                hwaccess: "hro"
                resval: "0"
            },
            {
                bits: "8"
                name: slw_pgm
                desc: '''
                      Slew programmability
                '''
                swaccess: "rw"
                hwaccess: "hro"
                resval: "1"
            },
            {
                bits: "9"
                name: trie
                desc: '''
                      Active high tri-state enable 
                '''
                swaccess: "rw"
                hwaccess: "hro"
                resval: "1"
            },
          ]
      }

       {
          name: HOST_00_MUX_SEL
          desc: '''
              Pad signal port multiplex selection for pad host_00. The programmed value defines which port
              is connected to the pad.
          '''
          swaccess: "rw"
          hwaccess: "hro"
          resval: 1
          fields: [
              {
                  bits: "0:0"
                  enum: [
                      { value: "0", name: "register", desc: "Connects the Pad to the internal configuration register."}
                      { value: "1", name: "port_uart0_host_rx", desc: "Connect port rx from port group uart0_host to this pad." }
                  ]
              }
          ]
      }

      {
          name: HOST_01_CFG
          desc: '''
            Pad signal configuration.
          '''
          swaccess: "rw"
          fields: [
            {
                bits: "0"
                name: chip2pad
                desc: '''
                     Data input pin from core
                '''
                swaccess: "rw"
                hwaccess: "hro"
                resval: "0"
            },
            {
                bits: "1"
                name: drv0
                desc: '''
                     Drive strength configuration bit 0 (LSB) 
                '''
                swaccess: "rw"
                hwaccess: "hro"
                resval: "1"
            },
            {
                bits: "2"
                name: drv1
                desc: '''
                     Drive strength configuration bit 1 
                '''
                swaccess: "rw"
                hwaccess: "hro"
                resval: "1"
            },
            {
                bits: "3"
                name: drv2
                desc: '''
                     Drive strength configuration bit 2 (MSB) 
                '''
                swaccess: "rw"
                hwaccess: "hro"
                resval: "1"
            },
            {
                bits: "4"
                name: pde
                desc: '''
                     active high weak pull-down enable
                '''
                swaccess: "rw"
                hwaccess: "hro"
                resval: "0"
            },
            {
                bits: "5"
                name: pp_odrain_selector
                desc: '''
                      Push-pull /Open Drain select pin 
                '''
                swaccess: "rw"
                hwaccess: "hro"
                resval: "1"
            },
            {
                bits: "6"
                name: pudis
                desc: '''
                     Active high disable weak pull-up
                '''
                swaccess: "rw"
                hwaccess: "hro"
                resval: "1"
            },
            {
                bits: "7"
                name: rxdis
                desc: '''
                     active high Disable receiver
                '''
                swaccess: "rw"
                hwaccess: "hro"
                resval: "0"
            },
            {
                bits: "8"
                name: slw_pgm
                desc: '''
                      Slew programmability
                '''
                swaccess: "rw"
                hwaccess: "hro"
                resval: "1"
            },
            {
                bits: "9"
                name: trie
                desc: '''
                      Active high tri-state enable 
                '''
                swaccess: "rw"
                hwaccess: "hro"
                resval: "1"
            },
          ]
      }

       {
          name: HOST_01_MUX_SEL
          desc: '''
              Pad signal port multiplex selection for pad host_01. The programmed value defines which port
              is connected to the pad.
          '''
          swaccess: "rw"
          hwaccess: "hro"
          resval: 1
          fields: [
              {
                  bits: "0:0"
                  enum: [
                      { value: "0", name: "register", desc: "Connects the Pad to the internal configuration register."}
                      { value: "1", name: "port_uart0_host_tx", desc: "Connect port tx from port group uart0_host to this pad." }
                  ]
              }
          ]
      }

      {
          name: HOST_02_CFG
          desc: '''
            Pad signal configuration.
          '''
          swaccess: "rw"
          fields: [
            {
                bits: "0"
                name: chip2pad
                desc: '''
                     Data input pin from core
                '''
                swaccess: "rw"
                hwaccess: "hro"
                resval: "0"
            },
            {
                bits: "1"
                name: drv0
                desc: '''
                     Drive strength configuration bit 0 (LSB) 
                '''
                swaccess: "rw"
                hwaccess: "hro"
                resval: "1"
            },
            {
                bits: "2"
                name: drv1
                desc: '''
                     Drive strength configuration bit 1 
                '''
                swaccess: "rw"
                hwaccess: "hro"
                resval: "1"
            },
            {
                bits: "3"
                name: drv2
                desc: '''
                     Drive strength configuration bit 2 (MSB) 
                '''
                swaccess: "rw"
                hwaccess: "hro"
                resval: "1"
            },
            {
                bits: "4"
                name: pde
                desc: '''
                     active high weak pull-down enable
                '''
                swaccess: "rw"
                hwaccess: "hro"
                resval: "0"
            },
            {
                bits: "5"
                name: pp_odrain_selector
                desc: '''
                      Push-pull /Open Drain select pin 
                '''
                swaccess: "rw"
                hwaccess: "hro"
                resval: "1"
            },
            {
                bits: "6"
                name: pudis
                desc: '''
                     Active high disable weak pull-up
                '''
                swaccess: "rw"
                hwaccess: "hro"
                resval: "1"
            },
            {
                bits: "7"
                name: rxdis
                desc: '''
                     active high Disable receiver
                '''
                swaccess: "rw"
                hwaccess: "hro"
                resval: "0"
            },
            {
                bits: "8"
                name: slw_pgm
                desc: '''
                      Slew programmability
                '''
                swaccess: "rw"
                hwaccess: "hro"
                resval: "1"
            },
            {
                bits: "9"
                name: trie
                desc: '''
                      Active high tri-state enable 
                '''
                swaccess: "rw"
                hwaccess: "hro"
                resval: "1"
            },
          ]
      }

       {
          name: HOST_02_MUX_SEL
          desc: '''
              Pad signal port multiplex selection for pad host_02. The programmed value defines which port
              is connected to the pad.
          '''
          swaccess: "rw"
          hwaccess: "hro"
          resval: 1
          fields: [
              {
                  bits: "0:0"
                  enum: [
                      { value: "0", name: "register", desc: "Connects the Pad to the internal configuration register."}
                      { value: "1", name: "port_qspi0_host_sdio0", desc: "Connect port sdio0 from port group qspi0_host to this pad." }
                  ]
              }
          ]
      }

      {
          name: HOST_03_CFG
          desc: '''
            Pad signal configuration.
          '''
          swaccess: "rw"
          fields: [
            {
                bits: "0"
                name: chip2pad
                desc: '''
                     Data input pin from core
                '''
                swaccess: "rw"
                hwaccess: "hro"
                resval: "0"
            },
            {
                bits: "1"
                name: drv0
                desc: '''
                     Drive strength configuration bit 0 (LSB) 
                '''
                swaccess: "rw"
                hwaccess: "hro"
                resval: "1"
            },
            {
                bits: "2"
                name: drv1
                desc: '''
                     Drive strength configuration bit 1 
                '''
                swaccess: "rw"
                hwaccess: "hro"
                resval: "1"
            },
            {
                bits: "3"
                name: drv2
                desc: '''
                     Drive strength configuration bit 2 (MSB) 
                '''
                swaccess: "rw"
                hwaccess: "hro"
                resval: "1"
            },
            {
                bits: "4"
                name: pde
                desc: '''
                     active high weak pull-down enable
                '''
                swaccess: "rw"
                hwaccess: "hro"
                resval: "0"
            },
            {
                bits: "5"
                name: pp_odrain_selector
                desc: '''
                      Push-pull /Open Drain select pin 
                '''
                swaccess: "rw"
                hwaccess: "hro"
                resval: "1"
            },
            {
                bits: "6"
                name: pudis
                desc: '''
                     Active high disable weak pull-up
                '''
                swaccess: "rw"
                hwaccess: "hro"
                resval: "1"
            },
            {
                bits: "7"
                name: rxdis
                desc: '''
                     active high Disable receiver
                '''
                swaccess: "rw"
                hwaccess: "hro"
                resval: "0"
            },
            {
                bits: "8"
                name: slw_pgm
                desc: '''
                      Slew programmability
                '''
                swaccess: "rw"
                hwaccess: "hro"
                resval: "1"
            },
            {
                bits: "9"
                name: trie
                desc: '''
                      Active high tri-state enable 
                '''
                swaccess: "rw"
                hwaccess: "hro"
                resval: "1"
            },
          ]
      }

       {
          name: HOST_03_MUX_SEL
          desc: '''
              Pad signal port multiplex selection for pad host_03. The programmed value defines which port
              is connected to the pad.
          '''
          swaccess: "rw"
          hwaccess: "hro"
          resval: 1
          fields: [
              {
                  bits: "0:0"
                  enum: [
                      { value: "0", name: "register", desc: "Connects the Pad to the internal configuration register."}
                      { value: "1", name: "port_qspi0_host_sdio1", desc: "Connect port sdio1 from port group qspi0_host to this pad." }
                  ]
              }
          ]
      }

      {
          name: HOST_04_CFG
          desc: '''
            Pad signal configuration.
          '''
          swaccess: "rw"
          fields: [
            {
                bits: "0"
                name: chip2pad
                desc: '''
                     Data input pin from core
                '''
                swaccess: "rw"
                hwaccess: "hro"
                resval: "0"
            },
            {
                bits: "1"
                name: drv0
                desc: '''
                     Drive strength configuration bit 0 (LSB) 
                '''
                swaccess: "rw"
                hwaccess: "hro"
                resval: "1"
            },
            {
                bits: "2"
                name: drv1
                desc: '''
                     Drive strength configuration bit 1 
                '''
                swaccess: "rw"
                hwaccess: "hro"
                resval: "1"
            },
            {
                bits: "3"
                name: drv2
                desc: '''
                     Drive strength configuration bit 2 (MSB) 
                '''
                swaccess: "rw"
                hwaccess: "hro"
                resval: "1"
            },
            {
                bits: "4"
                name: pde
                desc: '''
                     active high weak pull-down enable
                '''
                swaccess: "rw"
                hwaccess: "hro"
                resval: "0"
            },
            {
                bits: "5"
                name: pp_odrain_selector
                desc: '''
                      Push-pull /Open Drain select pin 
                '''
                swaccess: "rw"
                hwaccess: "hro"
                resval: "1"
            },
            {
                bits: "6"
                name: pudis
                desc: '''
                     Active high disable weak pull-up
                '''
                swaccess: "rw"
                hwaccess: "hro"
                resval: "1"
            },
            {
                bits: "7"
                name: rxdis
                desc: '''
                     active high Disable receiver
                '''
                swaccess: "rw"
                hwaccess: "hro"
                resval: "0"
            },
            {
                bits: "8"
                name: slw_pgm
                desc: '''
                      Slew programmability
                '''
                swaccess: "rw"
                hwaccess: "hro"
                resval: "1"
            },
            {
                bits: "9"
                name: trie
                desc: '''
                      Active high tri-state enable 
                '''
                swaccess: "rw"
                hwaccess: "hro"
                resval: "1"
            },
          ]
      }

       {
          name: HOST_04_MUX_SEL
          desc: '''
              Pad signal port multiplex selection for pad host_04. The programmed value defines which port
              is connected to the pad.
          '''
          swaccess: "rw"
          hwaccess: "hro"
          resval: 1
          fields: [
              {
                  bits: "0:0"
                  enum: [
                      { value: "0", name: "register", desc: "Connects the Pad to the internal configuration register."}
                      { value: "1", name: "port_qspi0_host_sdio2", desc: "Connect port sdio2 from port group qspi0_host to this pad." }
                  ]
              }
          ]
      }

      {
          name: HOST_05_CFG
          desc: '''
            Pad signal configuration.
          '''
          swaccess: "rw"
          fields: [
            {
                bits: "0"
                name: chip2pad
                desc: '''
                     Data input pin from core
                '''
                swaccess: "rw"
                hwaccess: "hro"
                resval: "0"
            },
            {
                bits: "1"
                name: drv0
                desc: '''
                     Drive strength configuration bit 0 (LSB) 
                '''
                swaccess: "rw"
                hwaccess: "hro"
                resval: "1"
            },
            {
                bits: "2"
                name: drv1
                desc: '''
                     Drive strength configuration bit 1 
                '''
                swaccess: "rw"
                hwaccess: "hro"
                resval: "1"
            },
            {
                bits: "3"
                name: drv2
                desc: '''
                     Drive strength configuration bit 2 (MSB) 
                '''
                swaccess: "rw"
                hwaccess: "hro"
                resval: "1"
            },
            {
                bits: "4"
                name: pde
                desc: '''
                     active high weak pull-down enable
                '''
                swaccess: "rw"
                hwaccess: "hro"
                resval: "0"
            },
            {
                bits: "5"
                name: pp_odrain_selector
                desc: '''
                      Push-pull /Open Drain select pin 
                '''
                swaccess: "rw"
                hwaccess: "hro"
                resval: "1"
            },
            {
                bits: "6"
                name: pudis
                desc: '''
                     Active high disable weak pull-up
                '''
                swaccess: "rw"
                hwaccess: "hro"
                resval: "1"
            },
            {
                bits: "7"
                name: rxdis
                desc: '''
                     active high Disable receiver
                '''
                swaccess: "rw"
                hwaccess: "hro"
                resval: "0"
            },
            {
                bits: "8"
                name: slw_pgm
                desc: '''
                      Slew programmability
                '''
                swaccess: "rw"
                hwaccess: "hro"
                resval: "1"
            },
            {
                bits: "9"
                name: trie
                desc: '''
                      Active high tri-state enable 
                '''
                swaccess: "rw"
                hwaccess: "hro"
                resval: "1"
            },
          ]
      }

       {
          name: HOST_05_MUX_SEL
          desc: '''
              Pad signal port multiplex selection for pad host_05. The programmed value defines which port
              is connected to the pad.
          '''
          swaccess: "rw"
          hwaccess: "hro"
          resval: 1
          fields: [
              {
                  bits: "0:0"
                  enum: [
                      { value: "0", name: "register", desc: "Connects the Pad to the internal configuration register."}
                      { value: "1", name: "port_qspi0_host_sdio3", desc: "Connect port sdio3 from port group qspi0_host to this pad." }
                  ]
              }
          ]
      }

      {
          name: HOST_06_CFG
          desc: '''
            Pad signal configuration.
          '''
          swaccess: "rw"
          fields: [
            {
                bits: "0"
                name: chip2pad
                desc: '''
                     Data input pin from core
                '''
                swaccess: "rw"
                hwaccess: "hro"
                resval: "0"
            },
            {
                bits: "1"
                name: drv0
                desc: '''
                     Drive strength configuration bit 0 (LSB) 
                '''
                swaccess: "rw"
                hwaccess: "hro"
                resval: "1"
            },
            {
                bits: "2"
                name: drv1
                desc: '''
                     Drive strength configuration bit 1 
                '''
                swaccess: "rw"
                hwaccess: "hro"
                resval: "1"
            },
            {
                bits: "3"
                name: drv2
                desc: '''
                     Drive strength configuration bit 2 (MSB) 
                '''
                swaccess: "rw"
                hwaccess: "hro"
                resval: "1"
            },
            {
                bits: "4"
                name: pde
                desc: '''
                     active high weak pull-down enable
                '''
                swaccess: "rw"
                hwaccess: "hro"
                resval: "0"
            },
            {
                bits: "5"
                name: pp_odrain_selector
                desc: '''
                      Push-pull /Open Drain select pin 
                '''
                swaccess: "rw"
                hwaccess: "hro"
                resval: "1"
            },
            {
                bits: "6"
                name: pudis
                desc: '''
                     Active high disable weak pull-up
                '''
                swaccess: "rw"
                hwaccess: "hro"
                resval: "1"
            },
            {
                bits: "7"
                name: rxdis
                desc: '''
                     active high Disable receiver
                '''
                swaccess: "rw"
                hwaccess: "hro"
                resval: "0"
            },
            {
                bits: "8"
                name: slw_pgm
                desc: '''
                      Slew programmability
                '''
                swaccess: "rw"
                hwaccess: "hro"
                resval: "1"
            },
            {
                bits: "9"
                name: trie
                desc: '''
                      Active high tri-state enable 
                '''
                swaccess: "rw"
                hwaccess: "hro"
                resval: "1"
            },
          ]
      }

       {
          name: HOST_06_MUX_SEL
          desc: '''
              Pad signal port multiplex selection for pad host_06. The programmed value defines which port
              is connected to the pad.
          '''
          swaccess: "rw"
          hwaccess: "hro"
          resval: 1
          fields: [
              {
                  bits: "0:0"
                  enum: [
                      { value: "0", name: "register", desc: "Connects the Pad to the internal configuration register."}
                      { value: "1", name: "port_qspi0_host_sck", desc: "Connect port sck from port group qspi0_host to this pad." }
                  ]
              }
          ]
      }

      {
          name: HOST_07_CFG
          desc: '''
            Pad signal configuration.
          '''
          swaccess: "rw"
          fields: [
            {
                bits: "0"
                name: chip2pad
                desc: '''
                     Data input pin from core
                '''
                swaccess: "rw"
                hwaccess: "hro"
                resval: "0"
            },
            {
                bits: "1"
                name: drv0
                desc: '''
                     Drive strength configuration bit 0 (LSB) 
                '''
                swaccess: "rw"
                hwaccess: "hro"
                resval: "1"
            },
            {
                bits: "2"
                name: drv1
                desc: '''
                     Drive strength configuration bit 1 
                '''
                swaccess: "rw"
                hwaccess: "hro"
                resval: "1"
            },
            {
                bits: "3"
                name: drv2
                desc: '''
                     Drive strength configuration bit 2 (MSB) 
                '''
                swaccess: "rw"
                hwaccess: "hro"
                resval: "1"
            },
            {
                bits: "4"
                name: pde
                desc: '''
                     active high weak pull-down enable
                '''
                swaccess: "rw"
                hwaccess: "hro"
                resval: "0"
            },
            {
                bits: "5"
                name: pp_odrain_selector
                desc: '''
                      Push-pull /Open Drain select pin 
                '''
                swaccess: "rw"
                hwaccess: "hro"
                resval: "1"
            },
            {
                bits: "6"
                name: pudis
                desc: '''
                     Active high disable weak pull-up
                '''
                swaccess: "rw"
                hwaccess: "hro"
                resval: "1"
            },
            {
                bits: "7"
                name: rxdis
                desc: '''
                     active high Disable receiver
                '''
                swaccess: "rw"
                hwaccess: "hro"
                resval: "0"
            },
            {
                bits: "8"
                name: slw_pgm
                desc: '''
                      Slew programmability
                '''
                swaccess: "rw"
                hwaccess: "hro"
                resval: "1"
            },
            {
                bits: "9"
                name: trie
                desc: '''
                      Active high tri-state enable 
                '''
                swaccess: "rw"
                hwaccess: "hro"
                resval: "1"
            },
          ]
      }

       {
          name: HOST_07_MUX_SEL
          desc: '''
              Pad signal port multiplex selection for pad host_07. The programmed value defines which port
              is connected to the pad.
          '''
          swaccess: "rw"
          hwaccess: "hro"
          resval: 1
          fields: [
              {
                  bits: "0:0"
                  enum: [
                      { value: "0", name: "register", desc: "Connects the Pad to the internal configuration register."}
                      { value: "1", name: "port_qspi0_host_csn0", desc: "Connect port csn0 from port group qspi0_host to this pad." }
                  ]
              }
          ]
      }

      {
          name: HOST_08_CFG
          desc: '''
            Pad signal configuration.
          '''
          swaccess: "rw"
          fields: [
            {
                bits: "0"
                name: chip2pad
                desc: '''
                     Data input pin from core
                '''
                swaccess: "rw"
                hwaccess: "hro"
                resval: "0"
            },
            {
                bits: "1"
                name: drv0
                desc: '''
                     Drive strength configuration bit 0 (LSB) 
                '''
                swaccess: "rw"
                hwaccess: "hro"
                resval: "1"
            },
            {
                bits: "2"
                name: drv1
                desc: '''
                     Drive strength configuration bit 1 
                '''
                swaccess: "rw"
                hwaccess: "hro"
                resval: "1"
            },
            {
                bits: "3"
                name: drv2
                desc: '''
                     Drive strength configuration bit 2 (MSB) 
                '''
                swaccess: "rw"
                hwaccess: "hro"
                resval: "1"
            },
            {
                bits: "4"
                name: pde
                desc: '''
                     active high weak pull-down enable
                '''
                swaccess: "rw"
                hwaccess: "hro"
                resval: "0"
            },
            {
                bits: "5"
                name: pp_odrain_selector
                desc: '''
                      Push-pull /Open Drain select pin 
                '''
                swaccess: "rw"
                hwaccess: "hro"
                resval: "1"
            },
            {
                bits: "6"
                name: pudis
                desc: '''
                     Active high disable weak pull-up
                '''
                swaccess: "rw"
                hwaccess: "hro"
                resval: "1"
            },
            {
                bits: "7"
                name: rxdis
                desc: '''
                     active high Disable receiver
                '''
                swaccess: "rw"
                hwaccess: "hro"
                resval: "0"
            },
            {
                bits: "8"
                name: slw_pgm
                desc: '''
                      Slew programmability
                '''
                swaccess: "rw"
                hwaccess: "hro"
                resval: "1"
            },
            {
                bits: "9"
                name: trie
                desc: '''
                      Active high tri-state enable 
                '''
                swaccess: "rw"
                hwaccess: "hro"
                resval: "1"
            },
          ]
      }

       {
          name: HOST_08_MUX_SEL
          desc: '''
              Pad signal port multiplex selection for pad host_08. The programmed value defines which port
              is connected to the pad.
          '''
          swaccess: "rw"
          hwaccess: "hro"
          resval: 1
          fields: [
              {
                  bits: "0:0"
                  enum: [
                      { value: "0", name: "register", desc: "Connects the Pad to the internal configuration register."}
                      { value: "1", name: "port_qspi0_host_csn1", desc: "Connect port csn1 from port group qspi0_host to this pad." }
                  ]
              }
          ]
      }

      {
          name: HOST_09_CFG
          desc: '''
            Pad signal configuration.
          '''
          swaccess: "rw"
          fields: [
            {
                bits: "0"
                name: chip2pad
                desc: '''
                     Data input pin from core
                '''
                swaccess: "rw"
                hwaccess: "hro"
                resval: "0"
            },
            {
                bits: "1"
                name: drv0
                desc: '''
                     Drive strength configuration bit 0 (LSB) 
                '''
                swaccess: "rw"
                hwaccess: "hro"
                resval: "1"
            },
            {
                bits: "2"
                name: drv1
                desc: '''
                     Drive strength configuration bit 1 
                '''
                swaccess: "rw"
                hwaccess: "hro"
                resval: "1"
            },
            {
                bits: "3"
                name: drv2
                desc: '''
                     Drive strength configuration bit 2 (MSB) 
                '''
                swaccess: "rw"
                hwaccess: "hro"
                resval: "1"
            },
            {
                bits: "4"
                name: pde
                desc: '''
                     active high weak pull-down enable
                '''
                swaccess: "rw"
                hwaccess: "hro"
                resval: "0"
            },
            {
                bits: "5"
                name: pp_odrain_selector
                desc: '''
                      Push-pull /Open Drain select pin 
                '''
                swaccess: "rw"
                hwaccess: "hro"
                resval: "1"
            },
            {
                bits: "6"
                name: pudis
                desc: '''
                     Active high disable weak pull-up
                '''
                swaccess: "rw"
                hwaccess: "hro"
                resval: "1"
            },
            {
                bits: "7"
                name: rxdis
                desc: '''
                     active high Disable receiver
                '''
                swaccess: "rw"
                hwaccess: "hro"
                resval: "0"
            },
            {
                bits: "8"
                name: slw_pgm
                desc: '''
                      Slew programmability
                '''
                swaccess: "rw"
                hwaccess: "hro"
                resval: "1"
            },
            {
                bits: "9"
                name: trie
                desc: '''
                      Active high tri-state enable 
                '''
                swaccess: "rw"
                hwaccess: "hro"
                resval: "1"
            },
          ]
      }

       {
          name: HOST_09_MUX_SEL
          desc: '''
              Pad signal port multiplex selection for pad host_09. The programmed value defines which port
              is connected to the pad.
          '''
          swaccess: "rw"
          hwaccess: "hro"
          resval: 1
          fields: [
              {
                  bits: "0:0"
                  enum: [
                      { value: "0", name: "register", desc: "Connects the Pad to the internal configuration register."}
                      { value: "1", name: "port_i2c0_host_sda", desc: "Connect port sda from port group i2c0_host to this pad." }
                  ]
              }
          ]
      }

      {
          name: HOST_10_CFG
          desc: '''
            Pad signal configuration.
          '''
          swaccess: "rw"
          fields: [
            {
                bits: "0"
                name: chip2pad
                desc: '''
                     Data input pin from core
                '''
                swaccess: "rw"
                hwaccess: "hro"
                resval: "0"
            },
            {
                bits: "1"
                name: drv0
                desc: '''
                     Drive strength configuration bit 0 (LSB) 
                '''
                swaccess: "rw"
                hwaccess: "hro"
                resval: "1"
            },
            {
                bits: "2"
                name: drv1
                desc: '''
                     Drive strength configuration bit 1 
                '''
                swaccess: "rw"
                hwaccess: "hro"
                resval: "1"
            },
            {
                bits: "3"
                name: drv2
                desc: '''
                     Drive strength configuration bit 2 (MSB) 
                '''
                swaccess: "rw"
                hwaccess: "hro"
                resval: "1"
            },
            {
                bits: "4"
                name: pde
                desc: '''
                     active high weak pull-down enable
                '''
                swaccess: "rw"
                hwaccess: "hro"
                resval: "0"
            },
            {
                bits: "5"
                name: pp_odrain_selector
                desc: '''
                      Push-pull /Open Drain select pin 
                '''
                swaccess: "rw"
                hwaccess: "hro"
                resval: "1"
            },
            {
                bits: "6"
                name: pudis
                desc: '''
                     Active high disable weak pull-up
                '''
                swaccess: "rw"
                hwaccess: "hro"
                resval: "1"
            },
            {
                bits: "7"
                name: rxdis
                desc: '''
                     active high Disable receiver
                '''
                swaccess: "rw"
                hwaccess: "hro"
                resval: "0"
            },
            {
                bits: "8"
                name: slw_pgm
                desc: '''
                      Slew programmability
                '''
                swaccess: "rw"
                hwaccess: "hro"
                resval: "1"
            },
            {
                bits: "9"
                name: trie
                desc: '''
                      Active high tri-state enable 
                '''
                swaccess: "rw"
                hwaccess: "hro"
                resval: "1"
            },
          ]
      }

       {
          name: HOST_10_MUX_SEL
          desc: '''
              Pad signal port multiplex selection for pad host_10. The programmed value defines which port
              is connected to the pad.
          '''
          swaccess: "rw"
          hwaccess: "hro"
          resval: 1
          fields: [
              {
                  bits: "0:0"
                  enum: [
                      { value: "0", name: "register", desc: "Connects the Pad to the internal configuration register."}
                      { value: "1", name: "port_i2c0_host_scl", desc: "Connect port scl from port group i2c0_host to this pad." }
                  ]
              }
          ]
      }















      {
          name: SECURE_00_CFG
          desc: '''
            Pad signal configuration.
          '''
          swaccess: "rw"
          fields: [
            {
                bits: "0"
                name: chip2pad
                desc: '''
                     Data input pin from core
                '''
                swaccess: "rw"
                hwaccess: "hro"
                resval: "0"
            },
            {
                bits: "1"
                name: drv0
                desc: '''
                     Drive strength configuration bit 0 (LSB) 
                '''
                swaccess: "rw"
                hwaccess: "hro"
                resval: "1"
            },
            {
                bits: "2"
                name: drv1
                desc: '''
                     Drive strength configuration bit 1 
                '''
                swaccess: "rw"
                hwaccess: "hro"
                resval: "1"
            },
            {
                bits: "3"
                name: drv2
                desc: '''
                     Drive strength configuration bit 2 (MSB) 
                '''
                swaccess: "rw"
                hwaccess: "hro"
                resval: "1"
            },
            {
                bits: "4"
                name: pde
                desc: '''
                     active high weak pull-down enable
                '''
                swaccess: "rw"
                hwaccess: "hro"
                resval: "0"
            },
            {
                bits: "5"
                name: pp_odrain_selector
                desc: '''
                      Push-pull /Open Drain select pin 
                '''
                swaccess: "rw"
                hwaccess: "hro"
                resval: "1"
            },
            {
                bits: "6"
                name: pudis
                desc: '''
                     Active high disable weak pull-up
                '''
                swaccess: "rw"
                hwaccess: "hro"
                resval: "1"
            },
            {
                bits: "7"
                name: rxdis
                desc: '''
                     active high Disable receiver
                '''
                swaccess: "rw"
                hwaccess: "hro"
                resval: "0"
            },
            {
                bits: "8"
                name: slw_pgm
                desc: '''
                      Slew programmability
                '''
                swaccess: "rw"
                hwaccess: "hro"
                resval: "1"
            },
            {
                bits: "9"
                name: trie
                desc: '''
                      Active high tri-state enable 
                '''
                swaccess: "rw"
                hwaccess: "hro"
                resval: "1"
            },
          ]
      }

       {
          name: SECURE_00_MUX_SEL
          desc: '''
              Pad signal port multiplex selection for pad secure_00. The programmed value defines which port
              is connected to the pad.
          '''
          swaccess: "rw"
          hwaccess: "hro"
          resval: 1
          fields: [
              {
                  bits: "0:0"
                  enum: [
                      { value: "0", name: "register", desc: "Connects the Pad to the internal configuration register."}
                      { value: "1", name: "port_qspi0_sec_isln_sdio0", desc: "Connect port sdio0 from port group qspi0_sec_isln to this pad." }
                  ]
              }
          ]
      }

      {
          name: SECURE_01_CFG
          desc: '''
            Pad signal configuration.
          '''
          swaccess: "rw"
          fields: [
            {
                bits: "0"
                name: chip2pad
                desc: '''
                     Data input pin from core
                '''
                swaccess: "rw"
                hwaccess: "hro"
                resval: "0"
            },
            {
                bits: "1"
                name: drv0
                desc: '''
                     Drive strength configuration bit 0 (LSB) 
                '''
                swaccess: "rw"
                hwaccess: "hro"
                resval: "1"
            },
            {
                bits: "2"
                name: drv1
                desc: '''
                     Drive strength configuration bit 1 
                '''
                swaccess: "rw"
                hwaccess: "hro"
                resval: "1"
            },
            {
                bits: "3"
                name: drv2
                desc: '''
                     Drive strength configuration bit 2 (MSB) 
                '''
                swaccess: "rw"
                hwaccess: "hro"
                resval: "1"
            },
            {
                bits: "4"
                name: pde
                desc: '''
                     active high weak pull-down enable
                '''
                swaccess: "rw"
                hwaccess: "hro"
                resval: "0"
            },
            {
                bits: "5"
                name: pp_odrain_selector
                desc: '''
                      Push-pull /Open Drain select pin 
                '''
                swaccess: "rw"
                hwaccess: "hro"
                resval: "1"
            },
            {
                bits: "6"
                name: pudis
                desc: '''
                     Active high disable weak pull-up
                '''
                swaccess: "rw"
                hwaccess: "hro"
                resval: "1"
            },
            {
                bits: "7"
                name: rxdis
                desc: '''
                     active high Disable receiver
                '''
                swaccess: "rw"
                hwaccess: "hro"
                resval: "0"
            },
            {
                bits: "8"
                name: slw_pgm
                desc: '''
                      Slew programmability
                '''
                swaccess: "rw"
                hwaccess: "hro"
                resval: "1"
            },
            {
                bits: "9"
                name: trie
                desc: '''
                      Active high tri-state enable 
                '''
                swaccess: "rw"
                hwaccess: "hro"
                resval: "1"
            },
          ]
      }

       {
          name: SECURE_01_MUX_SEL
          desc: '''
              Pad signal port multiplex selection for pad secure_01. The programmed value defines which port
              is connected to the pad.
          '''
          swaccess: "rw"
          hwaccess: "hro"
          resval: 1
          fields: [
              {
                  bits: "0:0"
                  enum: [
                      { value: "0", name: "register", desc: "Connects the Pad to the internal configuration register."}
                      { value: "1", name: "port_qspi0_sec_isln_sdio1", desc: "Connect port sdio1 from port group qspi0_sec_isln to this pad." }
                  ]
              }
          ]
      }

      {
          name: SECURE_02_CFG
          desc: '''
            Pad signal configuration.
          '''
          swaccess: "rw"
          fields: [
            {
                bits: "0"
                name: chip2pad
                desc: '''
                     Data input pin from core
                '''
                swaccess: "rw"
                hwaccess: "hro"
                resval: "0"
            },
            {
                bits: "1"
                name: drv0
                desc: '''
                     Drive strength configuration bit 0 (LSB) 
                '''
                swaccess: "rw"
                hwaccess: "hro"
                resval: "1"
            },
            {
                bits: "2"
                name: drv1
                desc: '''
                     Drive strength configuration bit 1 
                '''
                swaccess: "rw"
                hwaccess: "hro"
                resval: "1"
            },
            {
                bits: "3"
                name: drv2
                desc: '''
                     Drive strength configuration bit 2 (MSB) 
                '''
                swaccess: "rw"
                hwaccess: "hro"
                resval: "1"
            },
            {
                bits: "4"
                name: pde
                desc: '''
                     active high weak pull-down enable
                '''
                swaccess: "rw"
                hwaccess: "hro"
                resval: "0"
            },
            {
                bits: "5"
                name: pp_odrain_selector
                desc: '''
                      Push-pull /Open Drain select pin 
                '''
                swaccess: "rw"
                hwaccess: "hro"
                resval: "1"
            },
            {
                bits: "6"
                name: pudis
                desc: '''
                     Active high disable weak pull-up
                '''
                swaccess: "rw"
                hwaccess: "hro"
                resval: "1"
            },
            {
                bits: "7"
                name: rxdis
                desc: '''
                     active high Disable receiver
                '''
                swaccess: "rw"
                hwaccess: "hro"
                resval: "0"
            },
            {
                bits: "8"
                name: slw_pgm
                desc: '''
                      Slew programmability
                '''
                swaccess: "rw"
                hwaccess: "hro"
                resval: "1"
            },
            {
                bits: "9"
                name: trie
                desc: '''
                      Active high tri-state enable 
                '''
                swaccess: "rw"
                hwaccess: "hro"
                resval: "1"
            },
          ]
      }

       {
          name: SECURE_02_MUX_SEL
          desc: '''
              Pad signal port multiplex selection for pad secure_02. The programmed value defines which port
              is connected to the pad.
          '''
          swaccess: "rw"
          hwaccess: "hro"
          resval: 1
          fields: [
              {
                  bits: "0:0"
                  enum: [
                      { value: "0", name: "register", desc: "Connects the Pad to the internal configuration register."}
                      { value: "1", name: "port_qspi0_sec_isln_sdio2", desc: "Connect port sdio2 from port group qspi0_sec_isln to this pad." }
                  ]
              }
          ]
      }

      {
          name: SECURE_03_CFG
          desc: '''
            Pad signal configuration.
          '''
          swaccess: "rw"
          fields: [
            {
                bits: "0"
                name: chip2pad
                desc: '''
                     Data input pin from core
                '''
                swaccess: "rw"
                hwaccess: "hro"
                resval: "0"
            },
            {
                bits: "1"
                name: drv0
                desc: '''
                     Drive strength configuration bit 0 (LSB) 
                '''
                swaccess: "rw"
                hwaccess: "hro"
                resval: "1"
            },
            {
                bits: "2"
                name: drv1
                desc: '''
                     Drive strength configuration bit 1 
                '''
                swaccess: "rw"
                hwaccess: "hro"
                resval: "1"
            },
            {
                bits: "3"
                name: drv2
                desc: '''
                     Drive strength configuration bit 2 (MSB) 
                '''
                swaccess: "rw"
                hwaccess: "hro"
                resval: "1"
            },
            {
                bits: "4"
                name: pde
                desc: '''
                     active high weak pull-down enable
                '''
                swaccess: "rw"
                hwaccess: "hro"
                resval: "0"
            },
            {
                bits: "5"
                name: pp_odrain_selector
                desc: '''
                      Push-pull /Open Drain select pin 
                '''
                swaccess: "rw"
                hwaccess: "hro"
                resval: "1"
            },
            {
                bits: "6"
                name: pudis
                desc: '''
                     Active high disable weak pull-up
                '''
                swaccess: "rw"
                hwaccess: "hro"
                resval: "1"
            },
            {
                bits: "7"
                name: rxdis
                desc: '''
                     active high Disable receiver
                '''
                swaccess: "rw"
                hwaccess: "hro"
                resval: "0"
            },
            {
                bits: "8"
                name: slw_pgm
                desc: '''
                      Slew programmability
                '''
                swaccess: "rw"
                hwaccess: "hro"
                resval: "1"
            },
            {
                bits: "9"
                name: trie
                desc: '''
                      Active high tri-state enable 
                '''
                swaccess: "rw"
                hwaccess: "hro"
                resval: "1"
            },
          ]
      }

       {
          name: SECURE_03_MUX_SEL
          desc: '''
              Pad signal port multiplex selection for pad secure_03. The programmed value defines which port
              is connected to the pad.
          '''
          swaccess: "rw"
          hwaccess: "hro"
          resval: 1
          fields: [
              {
                  bits: "0:0"
                  enum: [
                      { value: "0", name: "register", desc: "Connects the Pad to the internal configuration register."}
                      { value: "1", name: "port_qspi0_sec_isln_sdio3", desc: "Connect port sdio3 from port group qspi0_sec_isln to this pad." }
                  ]
              }
          ]
      }

      {
          name: SECURE_04_CFG
          desc: '''
            Pad signal configuration.
          '''
          swaccess: "rw"
          fields: [
            {
                bits: "0"
                name: chip2pad
                desc: '''
                     Data input pin from core
                '''
                swaccess: "rw"
                hwaccess: "hro"
                resval: "0"
            },
            {
                bits: "1"
                name: drv0
                desc: '''
                     Drive strength configuration bit 0 (LSB) 
                '''
                swaccess: "rw"
                hwaccess: "hro"
                resval: "1"
            },
            {
                bits: "2"
                name: drv1
                desc: '''
                     Drive strength configuration bit 1 
                '''
                swaccess: "rw"
                hwaccess: "hro"
                resval: "1"
            },
            {
                bits: "3"
                name: drv2
                desc: '''
                     Drive strength configuration bit 2 (MSB) 
                '''
                swaccess: "rw"
                hwaccess: "hro"
                resval: "1"
            },
            {
                bits: "4"
                name: pde
                desc: '''
                     active high weak pull-down enable
                '''
                swaccess: "rw"
                hwaccess: "hro"
                resval: "0"
            },
            {
                bits: "5"
                name: pp_odrain_selector
                desc: '''
                      Push-pull /Open Drain select pin 
                '''
                swaccess: "rw"
                hwaccess: "hro"
                resval: "1"
            },
            {
                bits: "6"
                name: pudis
                desc: '''
                     Active high disable weak pull-up
                '''
                swaccess: "rw"
                hwaccess: "hro"
                resval: "1"
            },
            {
                bits: "7"
                name: rxdis
                desc: '''
                     active high Disable receiver
                '''
                swaccess: "rw"
                hwaccess: "hro"
                resval: "0"
            },
            {
                bits: "8"
                name: slw_pgm
                desc: '''
                      Slew programmability
                '''
                swaccess: "rw"
                hwaccess: "hro"
                resval: "1"
            },
            {
                bits: "9"
                name: trie
                desc: '''
                      Active high tri-state enable 
                '''
                swaccess: "rw"
                hwaccess: "hro"
                resval: "1"
            },
          ]
      }

       {
          name: SECURE_04_MUX_SEL
          desc: '''
              Pad signal port multiplex selection for pad secure_04. The programmed value defines which port
              is connected to the pad.
          '''
          swaccess: "rw"
          hwaccess: "hro"
          resval: 1
          fields: [
              {
                  bits: "0:0"
                  enum: [
                      { value: "0", name: "register", desc: "Connects the Pad to the internal configuration register."}
                      { value: "1", name: "port_qspi0_sec_isln_sck", desc: "Connect port sck from port group qspi0_sec_isln to this pad." }
                  ]
              }
          ]
      }

      {
          name: SECURE_05_CFG
          desc: '''
            Pad signal configuration.
          '''
          swaccess: "rw"
          fields: [
            {
                bits: "0"
                name: chip2pad
                desc: '''
                     Data input pin from core
                '''
                swaccess: "rw"
                hwaccess: "hro"
                resval: "0"
            },
            {
                bits: "1"
                name: drv0
                desc: '''
                     Drive strength configuration bit 0 (LSB) 
                '''
                swaccess: "rw"
                hwaccess: "hro"
                resval: "1"
            },
            {
                bits: "2"
                name: drv1
                desc: '''
                     Drive strength configuration bit 1 
                '''
                swaccess: "rw"
                hwaccess: "hro"
                resval: "1"
            },
            {
                bits: "3"
                name: drv2
                desc: '''
                     Drive strength configuration bit 2 (MSB) 
                '''
                swaccess: "rw"
                hwaccess: "hro"
                resval: "1"
            },
            {
                bits: "4"
                name: pde
                desc: '''
                     active high weak pull-down enable
                '''
                swaccess: "rw"
                hwaccess: "hro"
                resval: "0"
            },
            {
                bits: "5"
                name: pp_odrain_selector
                desc: '''
                      Push-pull /Open Drain select pin 
                '''
                swaccess: "rw"
                hwaccess: "hro"
                resval: "1"
            },
            {
                bits: "6"
                name: pudis
                desc: '''
                     Active high disable weak pull-up
                '''
                swaccess: "rw"
                hwaccess: "hro"
                resval: "1"
            },
            {
                bits: "7"
                name: rxdis
                desc: '''
                     active high Disable receiver
                '''
                swaccess: "rw"
                hwaccess: "hro"
                resval: "0"
            },
            {
                bits: "8"
                name: slw_pgm
                desc: '''
                      Slew programmability
                '''
                swaccess: "rw"
                hwaccess: "hro"
                resval: "1"
            },
            {
                bits: "9"
                name: trie
                desc: '''
                      Active high tri-state enable 
                '''
                swaccess: "rw"
                hwaccess: "hro"
                resval: "1"
            },
          ]
      }

       {
          name: SECURE_05_MUX_SEL
          desc: '''
              Pad signal port multiplex selection for pad secure_05. The programmed value defines which port
              is connected to the pad.
          '''
          swaccess: "rw"
          hwaccess: "hro"
          resval: 1
          fields: [
              {
                  bits: "0:0"
                  enum: [
                      { value: "0", name: "register", desc: "Connects the Pad to the internal configuration register."}
                      { value: "1", name: "port_qspi0_sec_isln_csn0", desc: "Connect port csn0 from port group qspi0_sec_isln to this pad." }
                  ]
              }
          ]
      }

      {
          name: SECURE_06_CFG
          desc: '''
            Pad signal configuration.
          '''
          swaccess: "rw"
          fields: [
            {
                bits: "0"
                name: chip2pad
                desc: '''
                     Data input pin from core
                '''
                swaccess: "rw"
                hwaccess: "hro"
                resval: "0"
            },
            {
                bits: "1"
                name: drv0
                desc: '''
                     Drive strength configuration bit 0 (LSB) 
                '''
                swaccess: "rw"
                hwaccess: "hro"
                resval: "1"
            },
            {
                bits: "2"
                name: drv1
                desc: '''
                     Drive strength configuration bit 1 
                '''
                swaccess: "rw"
                hwaccess: "hro"
                resval: "1"
            },
            {
                bits: "3"
                name: drv2
                desc: '''
                     Drive strength configuration bit 2 (MSB) 
                '''
                swaccess: "rw"
                hwaccess: "hro"
                resval: "1"
            },
            {
                bits: "4"
                name: pde
                desc: '''
                     active high weak pull-down enable
                '''
                swaccess: "rw"
                hwaccess: "hro"
                resval: "0"
            },
            {
                bits: "5"
                name: pp_odrain_selector
                desc: '''
                      Push-pull /Open Drain select pin 
                '''
                swaccess: "rw"
                hwaccess: "hro"
                resval: "1"
            },
            {
                bits: "6"
                name: pudis
                desc: '''
                     Active high disable weak pull-up
                '''
                swaccess: "rw"
                hwaccess: "hro"
                resval: "1"
            },
            {
                bits: "7"
                name: rxdis
                desc: '''
                     active high Disable receiver
                '''
                swaccess: "rw"
                hwaccess: "hro"
                resval: "0"
            },
            {
                bits: "8"
                name: slw_pgm
                desc: '''
                      Slew programmability
                '''
                swaccess: "rw"
                hwaccess: "hro"
                resval: "1"
            },
            {
                bits: "9"
                name: trie
                desc: '''
                      Active high tri-state enable 
                '''
                swaccess: "rw"
                hwaccess: "hro"
                resval: "1"
            },
          ]
      }

       {
          name: SECURE_06_MUX_SEL
          desc: '''
              Pad signal port multiplex selection for pad secure_06. The programmed value defines which port
              is connected to the pad.
          '''
          swaccess: "rw"
          hwaccess: "hro"
          resval: 1
          fields: [
              {
                  bits: "0:0"
                  enum: [
                      { value: "0", name: "register", desc: "Connects the Pad to the internal configuration register."}
                      { value: "1", name: "port_uart1_sec_isln_rx", desc: "Connect port rx from port group uart1_sec_isln to this pad." }
                  ]
              }
          ]
      }

      {
          name: SECURE_07_CFG
          desc: '''
            Pad signal configuration.
          '''
          swaccess: "rw"
          fields: [
            {
                bits: "0"
                name: chip2pad
                desc: '''
                     Data input pin from core
                '''
                swaccess: "rw"
                hwaccess: "hro"
                resval: "0"
            },
            {
                bits: "1"
                name: drv0
                desc: '''
                     Drive strength configuration bit 0 (LSB) 
                '''
                swaccess: "rw"
                hwaccess: "hro"
                resval: "1"
            },
            {
                bits: "2"
                name: drv1
                desc: '''
                     Drive strength configuration bit 1 
                '''
                swaccess: "rw"
                hwaccess: "hro"
                resval: "1"
            },
            {
                bits: "3"
                name: drv2
                desc: '''
                     Drive strength configuration bit 2 (MSB) 
                '''
                swaccess: "rw"
                hwaccess: "hro"
                resval: "1"
            },
            {
                bits: "4"
                name: pde
                desc: '''
                     active high weak pull-down enable
                '''
                swaccess: "rw"
                hwaccess: "hro"
                resval: "0"
            },
            {
                bits: "5"
                name: pp_odrain_selector
                desc: '''
                      Push-pull /Open Drain select pin 
                '''
                swaccess: "rw"
                hwaccess: "hro"
                resval: "1"
            },
            {
                bits: "6"
                name: pudis
                desc: '''
                     Active high disable weak pull-up
                '''
                swaccess: "rw"
                hwaccess: "hro"
                resval: "1"
            },
            {
                bits: "7"
                name: rxdis
                desc: '''
                     active high Disable receiver
                '''
                swaccess: "rw"
                hwaccess: "hro"
                resval: "0"
            },
            {
                bits: "8"
                name: slw_pgm
                desc: '''
                      Slew programmability
                '''
                swaccess: "rw"
                hwaccess: "hro"
                resval: "1"
            },
            {
                bits: "9"
                name: trie
                desc: '''
                      Active high tri-state enable 
                '''
                swaccess: "rw"
                hwaccess: "hro"
                resval: "1"
            },
          ]
      }

       {
          name: SECURE_07_MUX_SEL
          desc: '''
              Pad signal port multiplex selection for pad secure_07. The programmed value defines which port
              is connected to the pad.
          '''
          swaccess: "rw"
          hwaccess: "hro"
          resval: 1
          fields: [
              {
                  bits: "0:0"
                  enum: [
                      { value: "0", name: "register", desc: "Connects the Pad to the internal configuration register."}
                      { value: "1", name: "port_uart1_sec_isln_tx", desc: "Connect port tx from port group uart1_sec_isln to this pad." }
                  ]
              }
          ]
      }

      {
          name: GPIO_00_CFG
          desc: '''
            Pad signal configuration.
          '''
          swaccess: "rw"
          fields: [
            {
                bits: "0"
                name: chip2pad
                desc: '''
                     Data input pin from core
                '''
                swaccess: "rw"
                hwaccess: "hro"
                resval: "0"
            },
            {
                bits: "1"
                name: drv0
                desc: '''
                     Drive strength configuration bit 0 (LSB) 
                '''
                swaccess: "rw"
                hwaccess: "hro"
                resval: "1"
            },
            {
                bits: "2"
                name: drv1
                desc: '''
                     Drive strength configuration bit 1 
                '''
                swaccess: "rw"
                hwaccess: "hro"
                resval: "1"
            },
            {
                bits: "3"
                name: drv2
                desc: '''
                     Drive strength configuration bit 2 (MSB) 
                '''
                swaccess: "rw"
                hwaccess: "hro"
                resval: "1"
            },
            {
                bits: "4"
                name: pde
                desc: '''
                     active high weak pull-down enable
                '''
                swaccess: "rw"
                hwaccess: "hro"
                resval: "0"
            },
            {
                bits: "5"
                name: pp_odrain_selector
                desc: '''
                      Push-pull /Open Drain select pin 
                '''
                swaccess: "rw"
                hwaccess: "hro"
                resval: "1"
            },
            {
                bits: "6"
                name: pudis
                desc: '''
                     Active high disable weak pull-up
                '''
                swaccess: "rw"
                hwaccess: "hro"
                resval: "1"
            },
            {
                bits: "7"
                name: rxdis
                desc: '''
                     active high Disable receiver
                '''
                swaccess: "rw"
                hwaccess: "hro"
                resval: "0"
            },
            {
                bits: "8"
                name: slw_pgm
                desc: '''
                      Slew programmability
                '''
                swaccess: "rw"
                hwaccess: "hro"
                resval: "1"
            },
            {
                bits: "9"
                name: trie
                desc: '''
                      Active high tri-state enable 
                '''
                swaccess: "rw"
                hwaccess: "hro"
                resval: "1"
            },
          ]
      }

       {
          name: GPIO_00_MUX_SEL
          desc: '''
              Pad signal port multiplex selection for pad gpio_00. The programmed value defines which port
              is connected to the pad.
          '''
          swaccess: "rw"
          hwaccess: "hro"
          resval: 1
          fields: [
              {
                  bits: "0:0"
                  enum: [
                      { value: "0", name: "register", desc: "Connects the Pad to the internal configuration register."}
                      { value: "1", name: "port_gpio_gpio00", desc: "Connect port gpio00 from port group gpio to this pad." }
                  ]
              }
          ]
      }

      {
          name: GPIO_01_CFG
          desc: '''
            Pad signal configuration.
          '''
          swaccess: "rw"
          fields: [
            {
                bits: "0"
                name: chip2pad
                desc: '''
                     Data input pin from core
                '''
                swaccess: "rw"
                hwaccess: "hro"
                resval: "0"
            },
            {
                bits: "1"
                name: drv0
                desc: '''
                     Drive strength configuration bit 0 (LSB) 
                '''
                swaccess: "rw"
                hwaccess: "hro"
                resval: "1"
            },
            {
                bits: "2"
                name: drv1
                desc: '''
                     Drive strength configuration bit 1 
                '''
                swaccess: "rw"
                hwaccess: "hro"
                resval: "1"
            },
            {
                bits: "3"
                name: drv2
                desc: '''
                     Drive strength configuration bit 2 (MSB) 
                '''
                swaccess: "rw"
                hwaccess: "hro"
                resval: "1"
            },
            {
                bits: "4"
                name: pde
                desc: '''
                     active high weak pull-down enable
                '''
                swaccess: "rw"
                hwaccess: "hro"
                resval: "0"
            },
            {
                bits: "5"
                name: pp_odrain_selector
                desc: '''
                      Push-pull /Open Drain select pin 
                '''
                swaccess: "rw"
                hwaccess: "hro"
                resval: "1"
            },
            {
                bits: "6"
                name: pudis
                desc: '''
                     Active high disable weak pull-up
                '''
                swaccess: "rw"
                hwaccess: "hro"
                resval: "1"
            },
            {
                bits: "7"
                name: rxdis
                desc: '''
                     active high Disable receiver
                '''
                swaccess: "rw"
                hwaccess: "hro"
                resval: "0"
            },
            {
                bits: "8"
                name: slw_pgm
                desc: '''
                      Slew programmability
                '''
                swaccess: "rw"
                hwaccess: "hro"
                resval: "1"
            },
            {
                bits: "9"
                name: trie
                desc: '''
                      Active high tri-state enable 
                '''
                swaccess: "rw"
                hwaccess: "hro"
                resval: "1"
            },
          ]
      }

       {
          name: GPIO_01_MUX_SEL
          desc: '''
              Pad signal port multiplex selection for pad gpio_01. The programmed value defines which port
              is connected to the pad.
          '''
          swaccess: "rw"
          hwaccess: "hro"
          resval: 1
          fields: [
              {
                  bits: "0:0"
                  enum: [
                      { value: "0", name: "register", desc: "Connects the Pad to the internal configuration register."}
                      { value: "1", name: "port_gpio_gpio01", desc: "Connect port gpio01 from port group gpio to this pad." }
                  ]
              }
          ]
      }

      {
          name: GPIO_02_CFG
          desc: '''
            Pad signal configuration.
          '''
          swaccess: "rw"
          fields: [
            {
                bits: "0"
                name: chip2pad
                desc: '''
                     Data input pin from core
                '''
                swaccess: "rw"
                hwaccess: "hro"
                resval: "0"
            },
            {
                bits: "1"
                name: drv0
                desc: '''
                     Drive strength configuration bit 0 (LSB) 
                '''
                swaccess: "rw"
                hwaccess: "hro"
                resval: "1"
            },
            {
                bits: "2"
                name: drv1
                desc: '''
                     Drive strength configuration bit 1 
                '''
                swaccess: "rw"
                hwaccess: "hro"
                resval: "1"
            },
            {
                bits: "3"
                name: drv2
                desc: '''
                     Drive strength configuration bit 2 (MSB) 
                '''
                swaccess: "rw"
                hwaccess: "hro"
                resval: "1"
            },
            {
                bits: "4"
                name: pde
                desc: '''
                     active high weak pull-down enable
                '''
                swaccess: "rw"
                hwaccess: "hro"
                resval: "0"
            },
            {
                bits: "5"
                name: pp_odrain_selector
                desc: '''
                      Push-pull /Open Drain select pin 
                '''
                swaccess: "rw"
                hwaccess: "hro"
                resval: "1"
            },
            {
                bits: "6"
                name: pudis
                desc: '''
                     Active high disable weak pull-up
                '''
                swaccess: "rw"
                hwaccess: "hro"
                resval: "1"
            },
            {
                bits: "7"
                name: rxdis
                desc: '''
                     active high Disable receiver
                '''
                swaccess: "rw"
                hwaccess: "hro"
                resval: "0"
            },
            {
                bits: "8"
                name: slw_pgm
                desc: '''
                      Slew programmability
                '''
                swaccess: "rw"
                hwaccess: "hro"
                resval: "1"
            },
            {
                bits: "9"
                name: trie
                desc: '''
                      Active high tri-state enable 
                '''
                swaccess: "rw"
                hwaccess: "hro"
                resval: "1"
            },
          ]
      }

       {
          name: GPIO_02_MUX_SEL
          desc: '''
              Pad signal port multiplex selection for pad gpio_02. The programmed value defines which port
              is connected to the pad.
          '''
          swaccess: "rw"
          hwaccess: "hro"
          resval: 1
          fields: [
              {
                  bits: "0:0"
                  enum: [
                      { value: "0", name: "register", desc: "Connects the Pad to the internal configuration register."}
                      { value: "1", name: "port_gpio_gpio02", desc: "Connect port gpio02 from port group gpio to this pad." }
                  ]
              }
          ]
      }

      {
          name: GPIO_03_CFG
          desc: '''
            Pad signal configuration.
          '''
          swaccess: "rw"
          fields: [
            {
                bits: "0"
                name: chip2pad
                desc: '''
                     Data input pin from core
                '''
                swaccess: "rw"
                hwaccess: "hro"
                resval: "0"
            },
            {
                bits: "1"
                name: drv0
                desc: '''
                     Drive strength configuration bit 0 (LSB) 
                '''
                swaccess: "rw"
                hwaccess: "hro"
                resval: "1"
            },
            {
                bits: "2"
                name: drv1
                desc: '''
                     Drive strength configuration bit 1 
                '''
                swaccess: "rw"
                hwaccess: "hro"
                resval: "1"
            },
            {
                bits: "3"
                name: drv2
                desc: '''
                     Drive strength configuration bit 2 (MSB) 
                '''
                swaccess: "rw"
                hwaccess: "hro"
                resval: "1"
            },
            {
                bits: "4"
                name: pde
                desc: '''
                     active high weak pull-down enable
                '''
                swaccess: "rw"
                hwaccess: "hro"
                resval: "0"
            },
            {
                bits: "5"
                name: pp_odrain_selector
                desc: '''
                      Push-pull /Open Drain select pin 
                '''
                swaccess: "rw"
                hwaccess: "hro"
                resval: "1"
            },
            {
                bits: "6"
                name: pudis
                desc: '''
                     Active high disable weak pull-up
                '''
                swaccess: "rw"
                hwaccess: "hro"
                resval: "1"
            },
            {
                bits: "7"
                name: rxdis
                desc: '''
                     active high Disable receiver
                '''
                swaccess: "rw"
                hwaccess: "hro"
                resval: "0"
            },
            {
                bits: "8"
                name: slw_pgm
                desc: '''
                      Slew programmability
                '''
                swaccess: "rw"
                hwaccess: "hro"
                resval: "1"
            },
            {
                bits: "9"
                name: trie
                desc: '''
                      Active high tri-state enable 
                '''
                swaccess: "rw"
                hwaccess: "hro"
                resval: "1"
            },
          ]
      }

       {
          name: GPIO_03_MUX_SEL
          desc: '''
              Pad signal port multiplex selection for pad gpio_03. The programmed value defines which port
              is connected to the pad.
          '''
          swaccess: "rw"
          hwaccess: "hro"
          resval: 1
          fields: [
              {
                  bits: "0:0"
                  enum: [
                      { value: "0", name: "register", desc: "Connects the Pad to the internal configuration register."}
                      { value: "1", name: "port_gpio_gpio03", desc: "Connect port gpio03 from port group gpio to this pad." }
                  ]
              }
          ]
      }

      {
          name: GPIO_04_CFG
          desc: '''
            Pad signal configuration.
          '''
          swaccess: "rw"
          fields: [
            {
                bits: "0"
                name: chip2pad
                desc: '''
                     Data input pin from core
                '''
                swaccess: "rw"
                hwaccess: "hro"
                resval: "0"
            },
            {
                bits: "1"
                name: drv0
                desc: '''
                     Drive strength configuration bit 0 (LSB) 
                '''
                swaccess: "rw"
                hwaccess: "hro"
                resval: "1"
            },
            {
                bits: "2"
                name: drv1
                desc: '''
                     Drive strength configuration bit 1 
                '''
                swaccess: "rw"
                hwaccess: "hro"
                resval: "1"
            },
            {
                bits: "3"
                name: drv2
                desc: '''
                     Drive strength configuration bit 2 (MSB) 
                '''
                swaccess: "rw"
                hwaccess: "hro"
                resval: "1"
            },
            {
                bits: "4"
                name: pde
                desc: '''
                     active high weak pull-down enable
                '''
                swaccess: "rw"
                hwaccess: "hro"
                resval: "0"
            },
            {
                bits: "5"
                name: pp_odrain_selector
                desc: '''
                      Push-pull /Open Drain select pin 
                '''
                swaccess: "rw"
                hwaccess: "hro"
                resval: "1"
            },
            {
                bits: "6"
                name: pudis
                desc: '''
                     Active high disable weak pull-up
                '''
                swaccess: "rw"
                hwaccess: "hro"
                resval: "1"
            },
            {
                bits: "7"
                name: rxdis
                desc: '''
                     active high Disable receiver
                '''
                swaccess: "rw"
                hwaccess: "hro"
                resval: "0"
            },
            {
                bits: "8"
                name: slw_pgm
                desc: '''
                      Slew programmability
                '''
                swaccess: "rw"
                hwaccess: "hro"
                resval: "1"
            },
            {
                bits: "9"
                name: trie
                desc: '''
                      Active high tri-state enable 
                '''
                swaccess: "rw"
                hwaccess: "hro"
                resval: "1"
            },
          ]
      }

       {
          name: GPIO_04_MUX_SEL
          desc: '''
              Pad signal port multiplex selection for pad gpio_04. The programmed value defines which port
              is connected to the pad.
          '''
          swaccess: "rw"
          hwaccess: "hro"
          resval: 1
          fields: [
              {
                  bits: "0:0"
                  enum: [
                      { value: "0", name: "register", desc: "Connects the Pad to the internal configuration register."}
                      { value: "1", name: "port_gpio_gpio04", desc: "Connect port gpio04 from port group gpio to this pad." }
                  ]
              }
          ]
      }

      {
          name: GPIO_05_CFG
          desc: '''
            Pad signal configuration.
          '''
          swaccess: "rw"
          fields: [
            {
                bits: "0"
                name: chip2pad
                desc: '''
                     Data input pin from core
                '''
                swaccess: "rw"
                hwaccess: "hro"
                resval: "0"
            },
            {
                bits: "1"
                name: drv0
                desc: '''
                     Drive strength configuration bit 0 (LSB) 
                '''
                swaccess: "rw"
                hwaccess: "hro"
                resval: "1"
            },
            {
                bits: "2"
                name: drv1
                desc: '''
                     Drive strength configuration bit 1 
                '''
                swaccess: "rw"
                hwaccess: "hro"
                resval: "1"
            },
            {
                bits: "3"
                name: drv2
                desc: '''
                     Drive strength configuration bit 2 (MSB) 
                '''
                swaccess: "rw"
                hwaccess: "hro"
                resval: "1"
            },
            {
                bits: "4"
                name: pde
                desc: '''
                     active high weak pull-down enable
                '''
                swaccess: "rw"
                hwaccess: "hro"
                resval: "0"
            },
            {
                bits: "5"
                name: pp_odrain_selector
                desc: '''
                      Push-pull /Open Drain select pin 
                '''
                swaccess: "rw"
                hwaccess: "hro"
                resval: "1"
            },
            {
                bits: "6"
                name: pudis
                desc: '''
                     Active high disable weak pull-up
                '''
                swaccess: "rw"
                hwaccess: "hro"
                resval: "1"
            },
            {
                bits: "7"
                name: rxdis
                desc: '''
                     active high Disable receiver
                '''
                swaccess: "rw"
                hwaccess: "hro"
                resval: "0"
            },
            {
                bits: "8"
                name: slw_pgm
                desc: '''
                      Slew programmability
                '''
                swaccess: "rw"
                hwaccess: "hro"
                resval: "1"
            },
            {
                bits: "9"
                name: trie
                desc: '''
                      Active high tri-state enable 
                '''
                swaccess: "rw"
                hwaccess: "hro"
                resval: "1"
            },
          ]
      }

       {
          name: GPIO_05_MUX_SEL
          desc: '''
              Pad signal port multiplex selection for pad gpio_05. The programmed value defines which port
              is connected to the pad.
          '''
          swaccess: "rw"
          hwaccess: "hro"
          resval: 1
          fields: [
              {
                  bits: "0:0"
                  enum: [
                      { value: "0", name: "register", desc: "Connects the Pad to the internal configuration register."}
                      { value: "1", name: "port_gpio_gpio05", desc: "Connect port gpio05 from port group gpio to this pad." }
                  ]
              }
          ]
      }

      {
          name: GPIO_06_CFG
          desc: '''
            Pad signal configuration.
          '''
          swaccess: "rw"
          fields: [
            {
                bits: "0"
                name: chip2pad
                desc: '''
                     Data input pin from core
                '''
                swaccess: "rw"
                hwaccess: "hro"
                resval: "0"
            },
            {
                bits: "1"
                name: drv0
                desc: '''
                     Drive strength configuration bit 0 (LSB) 
                '''
                swaccess: "rw"
                hwaccess: "hro"
                resval: "1"
            },
            {
                bits: "2"
                name: drv1
                desc: '''
                     Drive strength configuration bit 1 
                '''
                swaccess: "rw"
                hwaccess: "hro"
                resval: "1"
            },
            {
                bits: "3"
                name: drv2
                desc: '''
                     Drive strength configuration bit 2 (MSB) 
                '''
                swaccess: "rw"
                hwaccess: "hro"
                resval: "1"
            },
            {
                bits: "4"
                name: pde
                desc: '''
                     active high weak pull-down enable
                '''
                swaccess: "rw"
                hwaccess: "hro"
                resval: "0"
            },
            {
                bits: "5"
                name: pp_odrain_selector
                desc: '''
                      Push-pull /Open Drain select pin 
                '''
                swaccess: "rw"
                hwaccess: "hro"
                resval: "1"
            },
            {
                bits: "6"
                name: pudis
                desc: '''
                     Active high disable weak pull-up
                '''
                swaccess: "rw"
                hwaccess: "hro"
                resval: "1"
            },
            {
                bits: "7"
                name: rxdis
                desc: '''
                     active high Disable receiver
                '''
                swaccess: "rw"
                hwaccess: "hro"
                resval: "0"
            },
            {
                bits: "8"
                name: slw_pgm
                desc: '''
                      Slew programmability
                '''
                swaccess: "rw"
                hwaccess: "hro"
                resval: "1"
            },
            {
                bits: "9"
                name: trie
                desc: '''
                      Active high tri-state enable 
                '''
                swaccess: "rw"
                hwaccess: "hro"
                resval: "1"
            },
          ]
      }

       {
          name: GPIO_06_MUX_SEL
          desc: '''
              Pad signal port multiplex selection for pad gpio_06. The programmed value defines which port
              is connected to the pad.
          '''
          swaccess: "rw"
          hwaccess: "hro"
          resval: 1
          fields: [
              {
                  bits: "0:0"
                  enum: [
                      { value: "0", name: "register", desc: "Connects the Pad to the internal configuration register."}
                      { value: "1", name: "port_gpio_gpio06", desc: "Connect port gpio06 from port group gpio to this pad." }
                  ]
              }
          ]
      }

      {
          name: GPIO_07_CFG
          desc: '''
            Pad signal configuration.
          '''
          swaccess: "rw"
          fields: [
            {
                bits: "0"
                name: chip2pad
                desc: '''
                     Data input pin from core
                '''
                swaccess: "rw"
                hwaccess: "hro"
                resval: "0"
            },
            {
                bits: "1"
                name: drv0
                desc: '''
                     Drive strength configuration bit 0 (LSB) 
                '''
                swaccess: "rw"
                hwaccess: "hro"
                resval: "1"
            },
            {
                bits: "2"
                name: drv1
                desc: '''
                     Drive strength configuration bit 1 
                '''
                swaccess: "rw"
                hwaccess: "hro"
                resval: "1"
            },
            {
                bits: "3"
                name: drv2
                desc: '''
                     Drive strength configuration bit 2 (MSB) 
                '''
                swaccess: "rw"
                hwaccess: "hro"
                resval: "1"
            },
            {
                bits: "4"
                name: pde
                desc: '''
                     active high weak pull-down enable
                '''
                swaccess: "rw"
                hwaccess: "hro"
                resval: "0"
            },
            {
                bits: "5"
                name: pp_odrain_selector
                desc: '''
                      Push-pull /Open Drain select pin 
                '''
                swaccess: "rw"
                hwaccess: "hro"
                resval: "1"
            },
            {
                bits: "6"
                name: pudis
                desc: '''
                     Active high disable weak pull-up
                '''
                swaccess: "rw"
                hwaccess: "hro"
                resval: "1"
            },
            {
                bits: "7"
                name: rxdis
                desc: '''
                     active high Disable receiver
                '''
                swaccess: "rw"
                hwaccess: "hro"
                resval: "0"
            },
            {
                bits: "8"
                name: slw_pgm
                desc: '''
                      Slew programmability
                '''
                swaccess: "rw"
                hwaccess: "hro"
                resval: "1"
            },
            {
                bits: "9"
                name: trie
                desc: '''
                      Active high tri-state enable 
                '''
                swaccess: "rw"
                hwaccess: "hro"
                resval: "1"
            },
          ]
      }

       {
          name: GPIO_07_MUX_SEL
          desc: '''
              Pad signal port multiplex selection for pad gpio_07. The programmed value defines which port
              is connected to the pad.
          '''
          swaccess: "rw"
          hwaccess: "hro"
          resval: 1
          fields: [
              {
                  bits: "0:0"
                  enum: [
                      { value: "0", name: "register", desc: "Connects the Pad to the internal configuration register."}
                      { value: "1", name: "port_gpio_gpio07", desc: "Connect port gpio07 from port group gpio to this pad." }
                  ]
              }
          ]
      }

      {
          name: GPIO_08_CFG
          desc: '''
            Pad signal configuration.
          '''
          swaccess: "rw"
          fields: [
            {
                bits: "0"
                name: chip2pad
                desc: '''
                     Data input pin from core
                '''
                swaccess: "rw"
                hwaccess: "hro"
                resval: "0"
            },
            {
                bits: "1"
                name: drv0
                desc: '''
                     Drive strength configuration bit 0 (LSB) 
                '''
                swaccess: "rw"
                hwaccess: "hro"
                resval: "1"
            },
            {
                bits: "2"
                name: drv1
                desc: '''
                     Drive strength configuration bit 1 
                '''
                swaccess: "rw"
                hwaccess: "hro"
                resval: "1"
            },
            {
                bits: "3"
                name: drv2
                desc: '''
                     Drive strength configuration bit 2 (MSB) 
                '''
                swaccess: "rw"
                hwaccess: "hro"
                resval: "1"
            },
            {
                bits: "4"
                name: pde
                desc: '''
                     active high weak pull-down enable
                '''
                swaccess: "rw"
                hwaccess: "hro"
                resval: "0"
            },
            {
                bits: "5"
                name: pp_odrain_selector
                desc: '''
                      Push-pull /Open Drain select pin 
                '''
                swaccess: "rw"
                hwaccess: "hro"
                resval: "1"
            },
            {
                bits: "6"
                name: pudis
                desc: '''
                     Active high disable weak pull-up
                '''
                swaccess: "rw"
                hwaccess: "hro"
                resval: "1"
            },
            {
                bits: "7"
                name: rxdis
                desc: '''
                     active high Disable receiver
                '''
                swaccess: "rw"
                hwaccess: "hro"
                resval: "0"
            },
            {
                bits: "8"
                name: slw_pgm
                desc: '''
                      Slew programmability
                '''
                swaccess: "rw"
                hwaccess: "hro"
                resval: "1"
            },
            {
                bits: "9"
                name: trie
                desc: '''
                      Active high tri-state enable 
                '''
                swaccess: "rw"
                hwaccess: "hro"
                resval: "1"
            },
          ]
      }

       {
          name: GPIO_08_MUX_SEL
          desc: '''
              Pad signal port multiplex selection for pad gpio_08. The programmed value defines which port
              is connected to the pad.
          '''
          swaccess: "rw"
          hwaccess: "hro"
          resval: 1
          fields: [
              {
                  bits: "0:0"
                  enum: [
                      { value: "0", name: "register", desc: "Connects the Pad to the internal configuration register."}
                      { value: "1", name: "port_gpio_gpio08", desc: "Connect port gpio08 from port group gpio to this pad." }
                  ]
              }
          ]
      }

      {
          name: GPIO_09_CFG
          desc: '''
            Pad signal configuration.
          '''
          swaccess: "rw"
          fields: [
            {
                bits: "0"
                name: chip2pad
                desc: '''
                     Data input pin from core
                '''
                swaccess: "rw"
                hwaccess: "hro"
                resval: "0"
            },
            {
                bits: "1"
                name: drv0
                desc: '''
                     Drive strength configuration bit 0 (LSB) 
                '''
                swaccess: "rw"
                hwaccess: "hro"
                resval: "1"
            },
            {
                bits: "2"
                name: drv1
                desc: '''
                     Drive strength configuration bit 1 
                '''
                swaccess: "rw"
                hwaccess: "hro"
                resval: "1"
            },
            {
                bits: "3"
                name: drv2
                desc: '''
                     Drive strength configuration bit 2 (MSB) 
                '''
                swaccess: "rw"
                hwaccess: "hro"
                resval: "1"
            },
            {
                bits: "4"
                name: pde
                desc: '''
                     active high weak pull-down enable
                '''
                swaccess: "rw"
                hwaccess: "hro"
                resval: "0"
            },
            {
                bits: "5"
                name: pp_odrain_selector
                desc: '''
                      Push-pull /Open Drain select pin 
                '''
                swaccess: "rw"
                hwaccess: "hro"
                resval: "1"
            },
            {
                bits: "6"
                name: pudis
                desc: '''
                     Active high disable weak pull-up
                '''
                swaccess: "rw"
                hwaccess: "hro"
                resval: "1"
            },
            {
                bits: "7"
                name: rxdis
                desc: '''
                     active high Disable receiver
                '''
                swaccess: "rw"
                hwaccess: "hro"
                resval: "0"
            },
            {
                bits: "8"
                name: slw_pgm
                desc: '''
                      Slew programmability
                '''
                swaccess: "rw"
                hwaccess: "hro"
                resval: "1"
            },
            {
                bits: "9"
                name: trie
                desc: '''
                      Active high tri-state enable 
                '''
                swaccess: "rw"
                hwaccess: "hro"
                resval: "1"
            },
          ]
      }

       {
          name: GPIO_09_MUX_SEL
          desc: '''
              Pad signal port multiplex selection for pad gpio_09. The programmed value defines which port
              is connected to the pad.
          '''
          swaccess: "rw"
          hwaccess: "hro"
          resval: 1
          fields: [
              {
                  bits: "0:0"
                  enum: [
                      { value: "0", name: "register", desc: "Connects the Pad to the internal configuration register."}
                      { value: "1", name: "port_gpio_gpio09", desc: "Connect port gpio09 from port group gpio to this pad." }
                  ]
              }
          ]
      }

      {
          name: GPIO_10_CFG
          desc: '''
            Pad signal configuration.
          '''
          swaccess: "rw"
          fields: [
            {
                bits: "0"
                name: chip2pad
                desc: '''
                     Data input pin from core
                '''
                swaccess: "rw"
                hwaccess: "hro"
                resval: "0"
            },
            {
                bits: "1"
                name: drv0
                desc: '''
                     Drive strength configuration bit 0 (LSB) 
                '''
                swaccess: "rw"
                hwaccess: "hro"
                resval: "1"
            },
            {
                bits: "2"
                name: drv1
                desc: '''
                     Drive strength configuration bit 1 
                '''
                swaccess: "rw"
                hwaccess: "hro"
                resval: "1"
            },
            {
                bits: "3"
                name: drv2
                desc: '''
                     Drive strength configuration bit 2 (MSB) 
                '''
                swaccess: "rw"
                hwaccess: "hro"
                resval: "1"
            },
            {
                bits: "4"
                name: pde
                desc: '''
                     active high weak pull-down enable
                '''
                swaccess: "rw"
                hwaccess: "hro"
                resval: "0"
            },
            {
                bits: "5"
                name: pp_odrain_selector
                desc: '''
                      Push-pull /Open Drain select pin 
                '''
                swaccess: "rw"
                hwaccess: "hro"
                resval: "1"
            },
            {
                bits: "6"
                name: pudis
                desc: '''
                     Active high disable weak pull-up
                '''
                swaccess: "rw"
                hwaccess: "hro"
                resval: "1"
            },
            {
                bits: "7"
                name: rxdis
                desc: '''
                     active high Disable receiver
                '''
                swaccess: "rw"
                hwaccess: "hro"
                resval: "0"
            },
            {
                bits: "8"
                name: slw_pgm
                desc: '''
                      Slew programmability
                '''
                swaccess: "rw"
                hwaccess: "hro"
                resval: "1"
            },
            {
                bits: "9"
                name: trie
                desc: '''
                      Active high tri-state enable 
                '''
                swaccess: "rw"
                hwaccess: "hro"
                resval: "1"
            },
          ]
      }

       {
          name: GPIO_10_MUX_SEL
          desc: '''
              Pad signal port multiplex selection for pad gpio_10. The programmed value defines which port
              is connected to the pad.
          '''
          swaccess: "rw"
          hwaccess: "hro"
          resval: 1
          fields: [
              {
                  bits: "0:0"
                  enum: [
                      { value: "0", name: "register", desc: "Connects the Pad to the internal configuration register."}
                      { value: "1", name: "port_gpio_gpio10", desc: "Connect port gpio10 from port group gpio to this pad." }
                  ]
              }
          ]
      }

      {
          name: GPIO_11_CFG
          desc: '''
            Pad signal configuration.
          '''
          swaccess: "rw"
          fields: [
            {
                bits: "0"
                name: chip2pad
                desc: '''
                     Data input pin from core
                '''
                swaccess: "rw"
                hwaccess: "hro"
                resval: "0"
            },
            {
                bits: "1"
                name: drv0
                desc: '''
                     Drive strength configuration bit 0 (LSB) 
                '''
                swaccess: "rw"
                hwaccess: "hro"
                resval: "1"
            },
            {
                bits: "2"
                name: drv1
                desc: '''
                     Drive strength configuration bit 1 
                '''
                swaccess: "rw"
                hwaccess: "hro"
                resval: "1"
            },
            {
                bits: "3"
                name: drv2
                desc: '''
                     Drive strength configuration bit 2 (MSB) 
                '''
                swaccess: "rw"
                hwaccess: "hro"
                resval: "1"
            },
            {
                bits: "4"
                name: pde
                desc: '''
                     active high weak pull-down enable
                '''
                swaccess: "rw"
                hwaccess: "hro"
                resval: "0"
            },
            {
                bits: "5"
                name: pp_odrain_selector
                desc: '''
                      Push-pull /Open Drain select pin 
                '''
                swaccess: "rw"
                hwaccess: "hro"
                resval: "1"
            },
            {
                bits: "6"
                name: pudis
                desc: '''
                     Active high disable weak pull-up
                '''
                swaccess: "rw"
                hwaccess: "hro"
                resval: "1"
            },
            {
                bits: "7"
                name: rxdis
                desc: '''
                     active high Disable receiver
                '''
                swaccess: "rw"
                hwaccess: "hro"
                resval: "0"
            },
            {
                bits: "8"
                name: slw_pgm
                desc: '''
                      Slew programmability
                '''
                swaccess: "rw"
                hwaccess: "hro"
                resval: "1"
            },
            {
                bits: "9"
                name: trie
                desc: '''
                      Active high tri-state enable 
                '''
                swaccess: "rw"
                hwaccess: "hro"
                resval: "1"
            },
          ]
      }

       {
          name: GPIO_11_MUX_SEL
          desc: '''
              Pad signal port multiplex selection for pad gpio_11. The programmed value defines which port
              is connected to the pad.
          '''
          swaccess: "rw"
          hwaccess: "hro"
          resval: 1
          fields: [
              {
                  bits: "0:0"
                  enum: [
                      { value: "0", name: "register", desc: "Connects the Pad to the internal configuration register."}
                      { value: "1", name: "port_gpio_gpio11", desc: "Connect port gpio11 from port group gpio to this pad." }
                  ]
              }
          ]
      }

      {
          name: GPIO_12_CFG
          desc: '''
            Pad signal configuration.
          '''
          swaccess: "rw"
          fields: [
            {
                bits: "0"
                name: chip2pad
                desc: '''
                     Data input pin from core
                '''
                swaccess: "rw"
                hwaccess: "hro"
                resval: "0"
            },
            {
                bits: "1"
                name: drv0
                desc: '''
                     Drive strength configuration bit 0 (LSB) 
                '''
                swaccess: "rw"
                hwaccess: "hro"
                resval: "1"
            },
            {
                bits: "2"
                name: drv1
                desc: '''
                     Drive strength configuration bit 1 
                '''
                swaccess: "rw"
                hwaccess: "hro"
                resval: "1"
            },
            {
                bits: "3"
                name: drv2
                desc: '''
                     Drive strength configuration bit 2 (MSB) 
                '''
                swaccess: "rw"
                hwaccess: "hro"
                resval: "1"
            },
            {
                bits: "4"
                name: pde
                desc: '''
                     active high weak pull-down enable
                '''
                swaccess: "rw"
                hwaccess: "hro"
                resval: "0"
            },
            {
                bits: "5"
                name: pp_odrain_selector
                desc: '''
                      Push-pull /Open Drain select pin 
                '''
                swaccess: "rw"
                hwaccess: "hro"
                resval: "1"
            },
            {
                bits: "6"
                name: pudis
                desc: '''
                     Active high disable weak pull-up
                '''
                swaccess: "rw"
                hwaccess: "hro"
                resval: "1"
            },
            {
                bits: "7"
                name: rxdis
                desc: '''
                     active high Disable receiver
                '''
                swaccess: "rw"
                hwaccess: "hro"
                resval: "0"
            },
            {
                bits: "8"
                name: slw_pgm
                desc: '''
                      Slew programmability
                '''
                swaccess: "rw"
                hwaccess: "hro"
                resval: "1"
            },
            {
                bits: "9"
                name: trie
                desc: '''
                      Active high tri-state enable 
                '''
                swaccess: "rw"
                hwaccess: "hro"
                resval: "1"
            },
          ]
      }

       {
          name: GPIO_12_MUX_SEL
          desc: '''
              Pad signal port multiplex selection for pad gpio_12. The programmed value defines which port
              is connected to the pad.
          '''
          swaccess: "rw"
          hwaccess: "hro"
          resval: 1
          fields: [
              {
                  bits: "0:0"
                  enum: [
                      { value: "0", name: "register", desc: "Connects the Pad to the internal configuration register."}
                      { value: "1", name: "port_gpio_gpio12", desc: "Connect port gpio12 from port group gpio to this pad." }
                  ]
              }
          ]
      }

      {
          name: GPIO_13_CFG
          desc: '''
            Pad signal configuration.
          '''
          swaccess: "rw"
          fields: [
            {
                bits: "0"
                name: chip2pad
                desc: '''
                     Data input pin from core
                '''
                swaccess: "rw"
                hwaccess: "hro"
                resval: "0"
            },
            {
                bits: "1"
                name: drv0
                desc: '''
                     Drive strength configuration bit 0 (LSB) 
                '''
                swaccess: "rw"
                hwaccess: "hro"
                resval: "1"
            },
            {
                bits: "2"
                name: drv1
                desc: '''
                     Drive strength configuration bit 1 
                '''
                swaccess: "rw"
                hwaccess: "hro"
                resval: "1"
            },
            {
                bits: "3"
                name: drv2
                desc: '''
                     Drive strength configuration bit 2 (MSB) 
                '''
                swaccess: "rw"
                hwaccess: "hro"
                resval: "1"
            },
            {
                bits: "4"
                name: pde
                desc: '''
                     active high weak pull-down enable
                '''
                swaccess: "rw"
                hwaccess: "hro"
                resval: "0"
            },
            {
                bits: "5"
                name: pp_odrain_selector
                desc: '''
                      Push-pull /Open Drain select pin 
                '''
                swaccess: "rw"
                hwaccess: "hro"
                resval: "1"
            },
            {
                bits: "6"
                name: pudis
                desc: '''
                     Active high disable weak pull-up
                '''
                swaccess: "rw"
                hwaccess: "hro"
                resval: "1"
            },
            {
                bits: "7"
                name: rxdis
                desc: '''
                     active high Disable receiver
                '''
                swaccess: "rw"
                hwaccess: "hro"
                resval: "0"
            },
            {
                bits: "8"
                name: slw_pgm
                desc: '''
                      Slew programmability
                '''
                swaccess: "rw"
                hwaccess: "hro"
                resval: "1"
            },
            {
                bits: "9"
                name: trie
                desc: '''
                      Active high tri-state enable 
                '''
                swaccess: "rw"
                hwaccess: "hro"
                resval: "1"
            },
          ]
      }

       {
          name: GPIO_13_MUX_SEL
          desc: '''
              Pad signal port multiplex selection for pad gpio_13. The programmed value defines which port
              is connected to the pad.
          '''
          swaccess: "rw"
          hwaccess: "hro"
          resval: 1
          fields: [
              {
                  bits: "0:0"
                  enum: [
                      { value: "0", name: "register", desc: "Connects the Pad to the internal configuration register."}
                      { value: "1", name: "port_gpio_gpio13", desc: "Connect port gpio13 from port group gpio to this pad." }
                  ]
              }
          ]
      }

      {
          name: GPIO_14_CFG
          desc: '''
            Pad signal configuration.
          '''
          swaccess: "rw"
          fields: [
            {
                bits: "0"
                name: chip2pad
                desc: '''
                     Data input pin from core
                '''
                swaccess: "rw"
                hwaccess: "hro"
                resval: "0"
            },
            {
                bits: "1"
                name: drv0
                desc: '''
                     Drive strength configuration bit 0 (LSB) 
                '''
                swaccess: "rw"
                hwaccess: "hro"
                resval: "1"
            },
            {
                bits: "2"
                name: drv1
                desc: '''
                     Drive strength configuration bit 1 
                '''
                swaccess: "rw"
                hwaccess: "hro"
                resval: "1"
            },
            {
                bits: "3"
                name: drv2
                desc: '''
                     Drive strength configuration bit 2 (MSB) 
                '''
                swaccess: "rw"
                hwaccess: "hro"
                resval: "1"
            },
            {
                bits: "4"
                name: pde
                desc: '''
                     active high weak pull-down enable
                '''
                swaccess: "rw"
                hwaccess: "hro"
                resval: "0"
            },
            {
                bits: "5"
                name: pp_odrain_selector
                desc: '''
                      Push-pull /Open Drain select pin 
                '''
                swaccess: "rw"
                hwaccess: "hro"
                resval: "1"
            },
            {
                bits: "6"
                name: pudis
                desc: '''
                     Active high disable weak pull-up
                '''
                swaccess: "rw"
                hwaccess: "hro"
                resval: "1"
            },
            {
                bits: "7"
                name: rxdis
                desc: '''
                     active high Disable receiver
                '''
                swaccess: "rw"
                hwaccess: "hro"
                resval: "0"
            },
            {
                bits: "8"
                name: slw_pgm
                desc: '''
                      Slew programmability
                '''
                swaccess: "rw"
                hwaccess: "hro"
                resval: "1"
            },
            {
                bits: "9"
                name: trie
                desc: '''
                      Active high tri-state enable 
                '''
                swaccess: "rw"
                hwaccess: "hro"
                resval: "1"
            },
          ]
      }

       {
          name: GPIO_14_MUX_SEL
          desc: '''
              Pad signal port multiplex selection for pad gpio_14. The programmed value defines which port
              is connected to the pad.
          '''
          swaccess: "rw"
          hwaccess: "hro"
          resval: 1
          fields: [
              {
                  bits: "0:0"
                  enum: [
                      { value: "0", name: "register", desc: "Connects the Pad to the internal configuration register."}
                      { value: "1", name: "port_gpio_gpio14", desc: "Connect port gpio14 from port group gpio to this pad." }
                  ]
              }
          ]
      }

      {
          name: GPIO_15_CFG
          desc: '''
            Pad signal configuration.
          '''
          swaccess: "rw"
          fields: [
            {
                bits: "0"
                name: chip2pad
                desc: '''
                     Data input pin from core
                '''
                swaccess: "rw"
                hwaccess: "hro"
                resval: "0"
            },
            {
                bits: "1"
                name: drv0
                desc: '''
                     Drive strength configuration bit 0 (LSB) 
                '''
                swaccess: "rw"
                hwaccess: "hro"
                resval: "1"
            },
            {
                bits: "2"
                name: drv1
                desc: '''
                     Drive strength configuration bit 1 
                '''
                swaccess: "rw"
                hwaccess: "hro"
                resval: "1"
            },
            {
                bits: "3"
                name: drv2
                desc: '''
                     Drive strength configuration bit 2 (MSB) 
                '''
                swaccess: "rw"
                hwaccess: "hro"
                resval: "1"
            },
            {
                bits: "4"
                name: pde
                desc: '''
                     active high weak pull-down enable
                '''
                swaccess: "rw"
                hwaccess: "hro"
                resval: "0"
            },
            {
                bits: "5"
                name: pp_odrain_selector
                desc: '''
                      Push-pull /Open Drain select pin 
                '''
                swaccess: "rw"
                hwaccess: "hro"
                resval: "1"
            },
            {
                bits: "6"
                name: pudis
                desc: '''
                     Active high disable weak pull-up
                '''
                swaccess: "rw"
                hwaccess: "hro"
                resval: "1"
            },
            {
                bits: "7"
                name: rxdis
                desc: '''
                     active high Disable receiver
                '''
                swaccess: "rw"
                hwaccess: "hro"
                resval: "0"
            },
            {
                bits: "8"
                name: slw_pgm
                desc: '''
                      Slew programmability
                '''
                swaccess: "rw"
                hwaccess: "hro"
                resval: "1"
            },
            {
                bits: "9"
                name: trie
                desc: '''
                      Active high tri-state enable 
                '''
                swaccess: "rw"
                hwaccess: "hro"
                resval: "1"
            },
          ]
      }

       {
          name: GPIO_15_MUX_SEL
          desc: '''
              Pad signal port multiplex selection for pad gpio_15. The programmed value defines which port
              is connected to the pad.
          '''
          swaccess: "rw"
          hwaccess: "hro"
          resval: 1
          fields: [
              {
                  bits: "0:0"
                  enum: [
                      { value: "0", name: "register", desc: "Connects the Pad to the internal configuration register."}
                      { value: "1", name: "port_gpio_gpio15", desc: "Connect port gpio15 from port group gpio to this pad." }
                  ]
              }
          ]
      }

      {
          name: PERIPH_00_CFG
          desc: '''
            Pad signal configuration.
          '''
          swaccess: "rw"
          fields: [
            {
                bits: "0"
                name: chip2pad
                desc: '''
                     Data input pin from core
                '''
                swaccess: "rw"
                hwaccess: "hro"
                resval: "0"
            },
            {
                bits: "1"
                name: drv0
                desc: '''
                     Drive strength configuration bit 0 (LSB) 
                '''
                swaccess: "rw"
                hwaccess: "hro"
                resval: "1"
            },
            {
                bits: "2"
                name: drv1
                desc: '''
                     Drive strength configuration bit 1 
                '''
                swaccess: "rw"
                hwaccess: "hro"
                resval: "1"
            },
            {
                bits: "3"
                name: drv2
                desc: '''
                     Drive strength configuration bit 2 (MSB) 
                '''
                swaccess: "rw"
                hwaccess: "hro"
                resval: "1"
            },
            {
                bits: "4"
                name: pde
                desc: '''
                     active high weak pull-down enable
                '''
                swaccess: "rw"
                hwaccess: "hro"
                resval: "0"
            },
            {
                bits: "5"
                name: pp_odrain_selector
                desc: '''
                      Push-pull /Open Drain select pin 
                '''
                swaccess: "rw"
                hwaccess: "hro"
                resval: "1"
            },
            {
                bits: "6"
                name: pudis
                desc: '''
                     Active high disable weak pull-up
                '''
                swaccess: "rw"
                hwaccess: "hro"
                resval: "1"
            },
            {
                bits: "7"
                name: rxdis
                desc: '''
                     active high Disable receiver
                '''
                swaccess: "rw"
                hwaccess: "hro"
                resval: "0"
            },
            {
                bits: "8"
                name: slw_pgm
                desc: '''
                      Slew programmability
                '''
                swaccess: "rw"
                hwaccess: "hro"
                resval: "1"
            },
            {
                bits: "9"
                name: trie
                desc: '''
                      Active high tri-state enable 
                '''
                swaccess: "rw"
                hwaccess: "hro"
                resval: "1"
            },
          ]
      }

       {
          name: PERIPH_00_MUX_SEL
          desc: '''
              Pad signal port multiplex selection for pad periph_00. The programmed value defines which port
              is connected to the pad.
          '''
          swaccess: "rw"
          hwaccess: "hro"
          resval: 1
          fields: [
              {
                  bits: "0:0"
                  enum: [
                      { value: "0", name: "register", desc: "Connects the Pad to the internal configuration register."}
                      { value: "1", name: "port_can0_tx", desc: "Connect port tx from port group can0 to this pad." }
                  ]
              }
          ]
      }

      {
          name: PERIPH_01_CFG
          desc: '''
            Pad signal configuration.
          '''
          swaccess: "rw"
          fields: [
            {
                bits: "0"
                name: chip2pad
                desc: '''
                     Data input pin from core
                '''
                swaccess: "rw"
                hwaccess: "hro"
                resval: "0"
            },
            {
                bits: "1"
                name: drv0
                desc: '''
                     Drive strength configuration bit 0 (LSB) 
                '''
                swaccess: "rw"
                hwaccess: "hro"
                resval: "1"
            },
            {
                bits: "2"
                name: drv1
                desc: '''
                     Drive strength configuration bit 1 
                '''
                swaccess: "rw"
                hwaccess: "hro"
                resval: "1"
            },
            {
                bits: "3"
                name: drv2
                desc: '''
                     Drive strength configuration bit 2 (MSB) 
                '''
                swaccess: "rw"
                hwaccess: "hro"
                resval: "1"
            },
            {
                bits: "4"
                name: pde
                desc: '''
                     active high weak pull-down enable
                '''
                swaccess: "rw"
                hwaccess: "hro"
                resval: "0"
            },
            {
                bits: "5"
                name: pp_odrain_selector
                desc: '''
                      Push-pull /Open Drain select pin 
                '''
                swaccess: "rw"
                hwaccess: "hro"
                resval: "1"
            },
            {
                bits: "6"
                name: pudis
                desc: '''
                     Active high disable weak pull-up
                '''
                swaccess: "rw"
                hwaccess: "hro"
                resval: "1"
            },
            {
                bits: "7"
                name: rxdis
                desc: '''
                     active high Disable receiver
                '''
                swaccess: "rw"
                hwaccess: "hro"
                resval: "0"
            },
            {
                bits: "8"
                name: slw_pgm
                desc: '''
                      Slew programmability
                '''
                swaccess: "rw"
                hwaccess: "hro"
                resval: "1"
            },
            {
                bits: "9"
                name: trie
                desc: '''
                      Active high tri-state enable 
                '''
                swaccess: "rw"
                hwaccess: "hro"
                resval: "1"
            },
          ]
      }

       {
          name: PERIPH_01_MUX_SEL
          desc: '''
              Pad signal port multiplex selection for pad periph_01. The programmed value defines which port
              is connected to the pad.
          '''
          swaccess: "rw"
          hwaccess: "hro"
          resval: 1
          fields: [
              {
                  bits: "0:0"
                  enum: [
                      { value: "0", name: "register", desc: "Connects the Pad to the internal configuration register."}
                      { value: "1", name: "port_can0_rx", desc: "Connect port rx from port group can0 to this pad." }
                  ]
              }
          ]
      }

      {
          name: PERIPH_02_CFG
          desc: '''
            Pad signal configuration.
          '''
          swaccess: "rw"
          fields: [
            {
                bits: "0"
                name: chip2pad
                desc: '''
                     Data input pin from core
                '''
                swaccess: "rw"
                hwaccess: "hro"
                resval: "0"
            },
            {
                bits: "1"
                name: drv0
                desc: '''
                     Drive strength configuration bit 0 (LSB) 
                '''
                swaccess: "rw"
                hwaccess: "hro"
                resval: "1"
            },
            {
                bits: "2"
                name: drv1
                desc: '''
                     Drive strength configuration bit 1 
                '''
                swaccess: "rw"
                hwaccess: "hro"
                resval: "1"
            },
            {
                bits: "3"
                name: drv2
                desc: '''
                     Drive strength configuration bit 2 (MSB) 
                '''
                swaccess: "rw"
                hwaccess: "hro"
                resval: "1"
            },
            {
                bits: "4"
                name: pde
                desc: '''
                     active high weak pull-down enable
                '''
                swaccess: "rw"
                hwaccess: "hro"
                resval: "0"
            },
            {
                bits: "5"
                name: pp_odrain_selector
                desc: '''
                      Push-pull /Open Drain select pin 
                '''
                swaccess: "rw"
                hwaccess: "hro"
                resval: "1"
            },
            {
                bits: "6"
                name: pudis
                desc: '''
                     Active high disable weak pull-up
                '''
                swaccess: "rw"
                hwaccess: "hro"
                resval: "1"
            },
            {
                bits: "7"
                name: rxdis
                desc: '''
                     active high Disable receiver
                '''
                swaccess: "rw"
                hwaccess: "hro"
                resval: "0"
            },
            {
                bits: "8"
                name: slw_pgm
                desc: '''
                      Slew programmability
                '''
                swaccess: "rw"
                hwaccess: "hro"
                resval: "1"
            },
            {
                bits: "9"
                name: trie
                desc: '''
                      Active high tri-state enable 
                '''
                swaccess: "rw"
                hwaccess: "hro"
                resval: "1"
            },
          ]
      }

       {
          name: PERIPH_02_MUX_SEL
          desc: '''
              Pad signal port multiplex selection for pad periph_02. The programmed value defines which port
              is connected to the pad.
          '''
          swaccess: "rw"
          hwaccess: "hro"
          resval: 1
          fields: [
              {
                  bits: "0:0"
                  enum: [
                      { value: "0", name: "register", desc: "Connects the Pad to the internal configuration register."}
                      { value: "1", name: "port_ethernet_eth_rst", desc: "Connect port eth_rst from port group ethernet to this pad." }
                  ]
              }
          ]
      }

      {
          name: PERIPH_03_CFG
          desc: '''
            Pad signal configuration.
          '''
          swaccess: "rw"
          fields: [
            {
                bits: "0"
                name: chip2pad
                desc: '''
                     Data input pin from core
                '''
                swaccess: "rw"
                hwaccess: "hro"
                resval: "0"
            },
            {
                bits: "1"
                name: drv0
                desc: '''
                     Drive strength configuration bit 0 (LSB) 
                '''
                swaccess: "rw"
                hwaccess: "hro"
                resval: "1"
            },
            {
                bits: "2"
                name: drv1
                desc: '''
                     Drive strength configuration bit 1 
                '''
                swaccess: "rw"
                hwaccess: "hro"
                resval: "1"
            },
            {
                bits: "3"
                name: drv2
                desc: '''
                     Drive strength configuration bit 2 (MSB) 
                '''
                swaccess: "rw"
                hwaccess: "hro"
                resval: "1"
            },
            {
                bits: "4"
                name: pde
                desc: '''
                     active high weak pull-down enable
                '''
                swaccess: "rw"
                hwaccess: "hro"
                resval: "0"
            },
            {
                bits: "5"
                name: pp_odrain_selector
                desc: '''
                      Push-pull /Open Drain select pin 
                '''
                swaccess: "rw"
                hwaccess: "hro"
                resval: "1"
            },
            {
                bits: "6"
                name: pudis
                desc: '''
                     Active high disable weak pull-up
                '''
                swaccess: "rw"
                hwaccess: "hro"
                resval: "1"
            },
            {
                bits: "7"
                name: rxdis
                desc: '''
                     active high Disable receiver
                '''
                swaccess: "rw"
                hwaccess: "hro"
                resval: "0"
            },
            {
                bits: "8"
                name: slw_pgm
                desc: '''
                      Slew programmability
                '''
                swaccess: "rw"
                hwaccess: "hro"
                resval: "1"
            },
            {
                bits: "9"
                name: trie
                desc: '''
                      Active high tri-state enable 
                '''
                swaccess: "rw"
                hwaccess: "hro"
                resval: "1"
            },
          ]
      }

       {
          name: PERIPH_03_MUX_SEL
          desc: '''
              Pad signal port multiplex selection for pad periph_03. The programmed value defines which port
              is connected to the pad.
          '''
          swaccess: "rw"
          hwaccess: "hro"
          resval: 1
          fields: [
              {
                  bits: "0:0"
                  enum: [
                      { value: "0", name: "register", desc: "Connects the Pad to the internal configuration register."}
                      { value: "1", name: "port_ethernet_eth_txck", desc: "Connect port eth_txck from port group ethernet to this pad." }
                  ]
              }
          ]
      }

      {
          name: PERIPH_04_CFG
          desc: '''
            Pad signal configuration.
          '''
          swaccess: "rw"
          fields: [
            {
                bits: "0"
                name: chip2pad
                desc: '''
                     Data input pin from core
                '''
                swaccess: "rw"
                hwaccess: "hro"
                resval: "0"
            },
            {
                bits: "1"
                name: drv0
                desc: '''
                     Drive strength configuration bit 0 (LSB) 
                '''
                swaccess: "rw"
                hwaccess: "hro"
                resval: "1"
            },
            {
                bits: "2"
                name: drv1
                desc: '''
                     Drive strength configuration bit 1 
                '''
                swaccess: "rw"
                hwaccess: "hro"
                resval: "1"
            },
            {
                bits: "3"
                name: drv2
                desc: '''
                     Drive strength configuration bit 2 (MSB) 
                '''
                swaccess: "rw"
                hwaccess: "hro"
                resval: "1"
            },
            {
                bits: "4"
                name: pde
                desc: '''
                     active high weak pull-down enable
                '''
                swaccess: "rw"
                hwaccess: "hro"
                resval: "0"
            },
            {
                bits: "5"
                name: pp_odrain_selector
                desc: '''
                      Push-pull /Open Drain select pin 
                '''
                swaccess: "rw"
                hwaccess: "hro"
                resval: "1"
            },
            {
                bits: "6"
                name: pudis
                desc: '''
                     Active high disable weak pull-up
                '''
                swaccess: "rw"
                hwaccess: "hro"
                resval: "1"
            },
            {
                bits: "7"
                name: rxdis
                desc: '''
                     active high Disable receiver
                '''
                swaccess: "rw"
                hwaccess: "hro"
                resval: "0"
            },
            {
                bits: "8"
                name: slw_pgm
                desc: '''
                      Slew programmability
                '''
                swaccess: "rw"
                hwaccess: "hro"
                resval: "1"
            },
            {
                bits: "9"
                name: trie
                desc: '''
                      Active high tri-state enable 
                '''
                swaccess: "rw"
                hwaccess: "hro"
                resval: "1"
            },
          ]
      }

       {
          name: PERIPH_04_MUX_SEL
          desc: '''
              Pad signal port multiplex selection for pad periph_04. The programmed value defines which port
              is connected to the pad.
          '''
          swaccess: "rw"
          hwaccess: "hro"
          resval: 1
          fields: [
              {
                  bits: "0:0"
                  enum: [
                      { value: "0", name: "register", desc: "Connects the Pad to the internal configuration register."}
                      { value: "1", name: "port_ethernet_eth_txctl", desc: "Connect port eth_txctl from port group ethernet to this pad." }
                  ]
              }
          ]
      }

      {
          name: PERIPH_05_CFG
          desc: '''
            Pad signal configuration.
          '''
          swaccess: "rw"
          fields: [
            {
                bits: "0"
                name: chip2pad
                desc: '''
                     Data input pin from core
                '''
                swaccess: "rw"
                hwaccess: "hro"
                resval: "0"
            },
            {
                bits: "1"
                name: drv0
                desc: '''
                     Drive strength configuration bit 0 (LSB) 
                '''
                swaccess: "rw"
                hwaccess: "hro"
                resval: "1"
            },
            {
                bits: "2"
                name: drv1
                desc: '''
                     Drive strength configuration bit 1 
                '''
                swaccess: "rw"
                hwaccess: "hro"
                resval: "1"
            },
            {
                bits: "3"
                name: drv2
                desc: '''
                     Drive strength configuration bit 2 (MSB) 
                '''
                swaccess: "rw"
                hwaccess: "hro"
                resval: "1"
            },
            {
                bits: "4"
                name: pde
                desc: '''
                     active high weak pull-down enable
                '''
                swaccess: "rw"
                hwaccess: "hro"
                resval: "0"
            },
            {
                bits: "5"
                name: pp_odrain_selector
                desc: '''
                      Push-pull /Open Drain select pin 
                '''
                swaccess: "rw"
                hwaccess: "hro"
                resval: "1"
            },
            {
                bits: "6"
                name: pudis
                desc: '''
                     Active high disable weak pull-up
                '''
                swaccess: "rw"
                hwaccess: "hro"
                resval: "1"
            },
            {
                bits: "7"
                name: rxdis
                desc: '''
                     active high Disable receiver
                '''
                swaccess: "rw"
                hwaccess: "hro"
                resval: "0"
            },
            {
                bits: "8"
                name: slw_pgm
                desc: '''
                      Slew programmability
                '''
                swaccess: "rw"
                hwaccess: "hro"
                resval: "1"
            },
            {
                bits: "9"
                name: trie
                desc: '''
                      Active high tri-state enable 
                '''
                swaccess: "rw"
                hwaccess: "hro"
                resval: "1"
            },
          ]
      }

       {
          name: PERIPH_05_MUX_SEL
          desc: '''
              Pad signal port multiplex selection for pad periph_05. The programmed value defines which port
              is connected to the pad.
          '''
          swaccess: "rw"
          hwaccess: "hro"
          resval: 1
          fields: [
              {
                  bits: "0:0"
                  enum: [
                      { value: "0", name: "register", desc: "Connects the Pad to the internal configuration register."}
                      { value: "1", name: "port_ethernet_eth_txd0", desc: "Connect port eth_txd0 from port group ethernet to this pad." }
                  ]
              }
          ]
      }

      {
          name: PERIPH_06_CFG
          desc: '''
            Pad signal configuration.
          '''
          swaccess: "rw"
          fields: [
            {
                bits: "0"
                name: chip2pad
                desc: '''
                     Data input pin from core
                '''
                swaccess: "rw"
                hwaccess: "hro"
                resval: "0"
            },
            {
                bits: "1"
                name: drv0
                desc: '''
                     Drive strength configuration bit 0 (LSB) 
                '''
                swaccess: "rw"
                hwaccess: "hro"
                resval: "1"
            },
            {
                bits: "2"
                name: drv1
                desc: '''
                     Drive strength configuration bit 1 
                '''
                swaccess: "rw"
                hwaccess: "hro"
                resval: "1"
            },
            {
                bits: "3"
                name: drv2
                desc: '''
                     Drive strength configuration bit 2 (MSB) 
                '''
                swaccess: "rw"
                hwaccess: "hro"
                resval: "1"
            },
            {
                bits: "4"
                name: pde
                desc: '''
                     active high weak pull-down enable
                '''
                swaccess: "rw"
                hwaccess: "hro"
                resval: "0"
            },
            {
                bits: "5"
                name: pp_odrain_selector
                desc: '''
                      Push-pull /Open Drain select pin 
                '''
                swaccess: "rw"
                hwaccess: "hro"
                resval: "1"
            },
            {
                bits: "6"
                name: pudis
                desc: '''
                     Active high disable weak pull-up
                '''
                swaccess: "rw"
                hwaccess: "hro"
                resval: "1"
            },
            {
                bits: "7"
                name: rxdis
                desc: '''
                     active high Disable receiver
                '''
                swaccess: "rw"
                hwaccess: "hro"
                resval: "0"
            },
            {
                bits: "8"
                name: slw_pgm
                desc: '''
                      Slew programmability
                '''
                swaccess: "rw"
                hwaccess: "hro"
                resval: "1"
            },
            {
                bits: "9"
                name: trie
                desc: '''
                      Active high tri-state enable 
                '''
                swaccess: "rw"
                hwaccess: "hro"
                resval: "1"
            },
          ]
      }

       {
          name: PERIPH_06_MUX_SEL
          desc: '''
              Pad signal port multiplex selection for pad periph_06. The programmed value defines which port
              is connected to the pad.
          '''
          swaccess: "rw"
          hwaccess: "hro"
          resval: 1
          fields: [
              {
                  bits: "0:0"
                  enum: [
                      { value: "0", name: "register", desc: "Connects the Pad to the internal configuration register."}
                      { value: "1", name: "port_ethernet_eth_txd1", desc: "Connect port eth_txd1 from port group ethernet to this pad." }
                  ]
              }
          ]
      }

      {
          name: PERIPH_07_CFG
          desc: '''
            Pad signal configuration.
          '''
          swaccess: "rw"
          fields: [
            {
                bits: "0"
                name: chip2pad
                desc: '''
                     Data input pin from core
                '''
                swaccess: "rw"
                hwaccess: "hro"
                resval: "0"
            },
            {
                bits: "1"
                name: drv0
                desc: '''
                     Drive strength configuration bit 0 (LSB) 
                '''
                swaccess: "rw"
                hwaccess: "hro"
                resval: "1"
            },
            {
                bits: "2"
                name: drv1
                desc: '''
                     Drive strength configuration bit 1 
                '''
                swaccess: "rw"
                hwaccess: "hro"
                resval: "1"
            },
            {
                bits: "3"
                name: drv2
                desc: '''
                     Drive strength configuration bit 2 (MSB) 
                '''
                swaccess: "rw"
                hwaccess: "hro"
                resval: "1"
            },
            {
                bits: "4"
                name: pde
                desc: '''
                     active high weak pull-down enable
                '''
                swaccess: "rw"
                hwaccess: "hro"
                resval: "0"
            },
            {
                bits: "5"
                name: pp_odrain_selector
                desc: '''
                      Push-pull /Open Drain select pin 
                '''
                swaccess: "rw"
                hwaccess: "hro"
                resval: "1"
            },
            {
                bits: "6"
                name: pudis
                desc: '''
                     Active high disable weak pull-up
                '''
                swaccess: "rw"
                hwaccess: "hro"
                resval: "1"
            },
            {
                bits: "7"
                name: rxdis
                desc: '''
                     active high Disable receiver
                '''
                swaccess: "rw"
                hwaccess: "hro"
                resval: "0"
            },
            {
                bits: "8"
                name: slw_pgm
                desc: '''
                      Slew programmability
                '''
                swaccess: "rw"
                hwaccess: "hro"
                resval: "1"
            },
            {
                bits: "9"
                name: trie
                desc: '''
                      Active high tri-state enable 
                '''
                swaccess: "rw"
                hwaccess: "hro"
                resval: "1"
            },
          ]
      }

       {
          name: PERIPH_07_MUX_SEL
          desc: '''
              Pad signal port multiplex selection for pad periph_07. The programmed value defines which port
              is connected to the pad.
          '''
          swaccess: "rw"
          hwaccess: "hro"
          resval: 1
          fields: [
              {
                  bits: "0:0"
                  enum: [
                      { value: "0", name: "register", desc: "Connects the Pad to the internal configuration register."}
                      { value: "1", name: "port_ethernet_eth_txd2", desc: "Connect port eth_txd2 from port group ethernet to this pad." }
                  ]
              }
          ]
      }

      {
          name: PERIPH_08_CFG
          desc: '''
            Pad signal configuration.
          '''
          swaccess: "rw"
          fields: [
            {
                bits: "0"
                name: chip2pad
                desc: '''
                     Data input pin from core
                '''
                swaccess: "rw"
                hwaccess: "hro"
                resval: "0"
            },
            {
                bits: "1"
                name: drv0
                desc: '''
                     Drive strength configuration bit 0 (LSB) 
                '''
                swaccess: "rw"
                hwaccess: "hro"
                resval: "1"
            },
            {
                bits: "2"
                name: drv1
                desc: '''
                     Drive strength configuration bit 1 
                '''
                swaccess: "rw"
                hwaccess: "hro"
                resval: "1"
            },
            {
                bits: "3"
                name: drv2
                desc: '''
                     Drive strength configuration bit 2 (MSB) 
                '''
                swaccess: "rw"
                hwaccess: "hro"
                resval: "1"
            },
            {
                bits: "4"
                name: pde
                desc: '''
                     active high weak pull-down enable
                '''
                swaccess: "rw"
                hwaccess: "hro"
                resval: "0"
            },
            {
                bits: "5"
                name: pp_odrain_selector
                desc: '''
                      Push-pull /Open Drain select pin 
                '''
                swaccess: "rw"
                hwaccess: "hro"
                resval: "1"
            },
            {
                bits: "6"
                name: pudis
                desc: '''
                     Active high disable weak pull-up
                '''
                swaccess: "rw"
                hwaccess: "hro"
                resval: "1"
            },
            {
                bits: "7"
                name: rxdis
                desc: '''
                     active high Disable receiver
                '''
                swaccess: "rw"
                hwaccess: "hro"
                resval: "0"
            },
            {
                bits: "8"
                name: slw_pgm
                desc: '''
                      Slew programmability
                '''
                swaccess: "rw"
                hwaccess: "hro"
                resval: "1"
            },
            {
                bits: "9"
                name: trie
                desc: '''
                      Active high tri-state enable 
                '''
                swaccess: "rw"
                hwaccess: "hro"
                resval: "1"
            },
          ]
      }

       {
          name: PERIPH_08_MUX_SEL
          desc: '''
              Pad signal port multiplex selection for pad periph_08. The programmed value defines which port
              is connected to the pad.
          '''
          swaccess: "rw"
          hwaccess: "hro"
          resval: 1
          fields: [
              {
                  bits: "0:0"
                  enum: [
                      { value: "0", name: "register", desc: "Connects the Pad to the internal configuration register."}
                      { value: "1", name: "port_ethernet_eth_txd3", desc: "Connect port eth_txd3 from port group ethernet to this pad." }
                  ]
              }
          ]
      }

      {
          name: PERIPH_09_CFG
          desc: '''
            Pad signal configuration.
          '''
          swaccess: "rw"
          fields: [
            {
                bits: "0"
                name: chip2pad
                desc: '''
                     Data input pin from core
                '''
                swaccess: "rw"
                hwaccess: "hro"
                resval: "0"
            },
            {
                bits: "1"
                name: drv0
                desc: '''
                     Drive strength configuration bit 0 (LSB) 
                '''
                swaccess: "rw"
                hwaccess: "hro"
                resval: "1"
            },
            {
                bits: "2"
                name: drv1
                desc: '''
                     Drive strength configuration bit 1 
                '''
                swaccess: "rw"
                hwaccess: "hro"
                resval: "1"
            },
            {
                bits: "3"
                name: drv2
                desc: '''
                     Drive strength configuration bit 2 (MSB) 
                '''
                swaccess: "rw"
                hwaccess: "hro"
                resval: "1"
            },
            {
                bits: "4"
                name: pde
                desc: '''
                     active high weak pull-down enable
                '''
                swaccess: "rw"
                hwaccess: "hro"
                resval: "0"
            },
            {
                bits: "5"
                name: pp_odrain_selector
                desc: '''
                      Push-pull /Open Drain select pin 
                '''
                swaccess: "rw"
                hwaccess: "hro"
                resval: "1"
            },
            {
                bits: "6"
                name: pudis
                desc: '''
                     Active high disable weak pull-up
                '''
                swaccess: "rw"
                hwaccess: "hro"
                resval: "1"
            },
            {
                bits: "7"
                name: rxdis
                desc: '''
                     active high Disable receiver
                '''
                swaccess: "rw"
                hwaccess: "hro"
                resval: "0"
            },
            {
                bits: "8"
                name: slw_pgm
                desc: '''
                      Slew programmability
                '''
                swaccess: "rw"
                hwaccess: "hro"
                resval: "1"
            },
            {
                bits: "9"
                name: trie
                desc: '''
                      Active high tri-state enable 
                '''
                swaccess: "rw"
                hwaccess: "hro"
                resval: "1"
            },
          ]
      }

       {
          name: PERIPH_09_MUX_SEL
          desc: '''
              Pad signal port multiplex selection for pad periph_09. The programmed value defines which port
              is connected to the pad.
          '''
          swaccess: "rw"
          hwaccess: "hro"
          resval: 1
          fields: [
              {
                  bits: "0:0"
                  enum: [
                      { value: "0", name: "register", desc: "Connects the Pad to the internal configuration register."}
                      { value: "1", name: "port_ethernet_eth_mdc", desc: "Connect port eth_mdc from port group ethernet to this pad." }
                  ]
              }
          ]
      }

      {
          name: PERIPH_10_CFG
          desc: '''
            Pad signal configuration.
          '''
          swaccess: "rw"
          fields: [
            {
                bits: "0"
                name: chip2pad
                desc: '''
                     Data input pin from core
                '''
                swaccess: "rw"
                hwaccess: "hro"
                resval: "0"
            },
            {
                bits: "1"
                name: drv0
                desc: '''
                     Drive strength configuration bit 0 (LSB) 
                '''
                swaccess: "rw"
                hwaccess: "hro"
                resval: "1"
            },
            {
                bits: "2"
                name: drv1
                desc: '''
                     Drive strength configuration bit 1 
                '''
                swaccess: "rw"
                hwaccess: "hro"
                resval: "1"
            },
            {
                bits: "3"
                name: drv2
                desc: '''
                     Drive strength configuration bit 2 (MSB) 
                '''
                swaccess: "rw"
                hwaccess: "hro"
                resval: "1"
            },
            {
                bits: "4"
                name: pde
                desc: '''
                     active high weak pull-down enable
                '''
                swaccess: "rw"
                hwaccess: "hro"
                resval: "0"
            },
            {
                bits: "5"
                name: pp_odrain_selector
                desc: '''
                      Push-pull /Open Drain select pin 
                '''
                swaccess: "rw"
                hwaccess: "hro"
                resval: "1"
            },
            {
                bits: "6"
                name: pudis
                desc: '''
                     Active high disable weak pull-up
                '''
                swaccess: "rw"
                hwaccess: "hro"
                resval: "1"
            },
            {
                bits: "7"
                name: rxdis
                desc: '''
                     active high Disable receiver
                '''
                swaccess: "rw"
                hwaccess: "hro"
                resval: "0"
            },
            {
                bits: "8"
                name: slw_pgm
                desc: '''
                      Slew programmability
                '''
                swaccess: "rw"
                hwaccess: "hro"
                resval: "1"
            },
            {
                bits: "9"
                name: trie
                desc: '''
                      Active high tri-state enable 
                '''
                swaccess: "rw"
                hwaccess: "hro"
                resval: "1"
            },
          ]
      }

       {
          name: PERIPH_10_MUX_SEL
          desc: '''
              Pad signal port multiplex selection for pad periph_10. The programmed value defines which port
              is connected to the pad.
          '''
          swaccess: "rw"
          hwaccess: "hro"
          resval: 1
          fields: [
              {
                  bits: "0:0"
                  enum: [
                      { value: "0", name: "register", desc: "Connects the Pad to the internal configuration register."}
                      { value: "1", name: "port_ethernet_eth_mdio", desc: "Connect port eth_mdio from port group ethernet to this pad." }
                  ]
              }
          ]
      }

      {
          name: PERIPH_11_CFG
          desc: '''
            Pad signal configuration.
          '''
          swaccess: "rw"
          fields: [
            {
                bits: "0"
                name: chip2pad
                desc: '''
                     Data input pin from core
                '''
                swaccess: "rw"
                hwaccess: "hro"
                resval: "0"
            },
            {
                bits: "1"
                name: drv0
                desc: '''
                     Drive strength configuration bit 0 (LSB) 
                '''
                swaccess: "rw"
                hwaccess: "hro"
                resval: "1"
            },
            {
                bits: "2"
                name: drv1
                desc: '''
                     Drive strength configuration bit 1 
                '''
                swaccess: "rw"
                hwaccess: "hro"
                resval: "1"
            },
            {
                bits: "3"
                name: drv2
                desc: '''
                     Drive strength configuration bit 2 (MSB) 
                '''
                swaccess: "rw"
                hwaccess: "hro"
                resval: "1"
            },
            {
                bits: "4"
                name: pde
                desc: '''
                     active high weak pull-down enable
                '''
                swaccess: "rw"
                hwaccess: "hro"
                resval: "0"
            },
            {
                bits: "5"
                name: pp_odrain_selector
                desc: '''
                      Push-pull /Open Drain select pin 
                '''
                swaccess: "rw"
                hwaccess: "hro"
                resval: "1"
            },
            {
                bits: "6"
                name: pudis
                desc: '''
                     Active high disable weak pull-up
                '''
                swaccess: "rw"
                hwaccess: "hro"
                resval: "1"
            },
            {
                bits: "7"
                name: rxdis
                desc: '''
                     active high Disable receiver
                '''
                swaccess: "rw"
                hwaccess: "hro"
                resval: "0"
            },
            {
                bits: "8"
                name: slw_pgm
                desc: '''
                      Slew programmability
                '''
                swaccess: "rw"
                hwaccess: "hro"
                resval: "1"
            },
            {
                bits: "9"
                name: trie
                desc: '''
                      Active high tri-state enable 
                '''
                swaccess: "rw"
                hwaccess: "hro"
                resval: "1"
            },
          ]
      }

       {
          name: PERIPH_11_MUX_SEL
          desc: '''
              Pad signal port multiplex selection for pad periph_11. The programmed value defines which port
              is connected to the pad.
          '''
          swaccess: "rw"
          hwaccess: "hro"
          resval: 1
          fields: [
              {
                  bits: "0:0"
                  enum: [
                      { value: "0", name: "register", desc: "Connects the Pad to the internal configuration register."}
                      { value: "1", name: "port_ethernet_eth_rxck", desc: "Connect port eth_rxck from port group ethernet to this pad." }
                  ]
              }
          ]
      }

      {
          name: PERIPH_12_CFG
          desc: '''
            Pad signal configuration.
          '''
          swaccess: "rw"
          fields: [
            {
                bits: "0"
                name: chip2pad
                desc: '''
                     Data input pin from core
                '''
                swaccess: "rw"
                hwaccess: "hro"
                resval: "0"
            },
            {
                bits: "1"
                name: drv0
                desc: '''
                     Drive strength configuration bit 0 (LSB) 
                '''
                swaccess: "rw"
                hwaccess: "hro"
                resval: "1"
            },
            {
                bits: "2"
                name: drv1
                desc: '''
                     Drive strength configuration bit 1 
                '''
                swaccess: "rw"
                hwaccess: "hro"
                resval: "1"
            },
            {
                bits: "3"
                name: drv2
                desc: '''
                     Drive strength configuration bit 2 (MSB) 
                '''
                swaccess: "rw"
                hwaccess: "hro"
                resval: "1"
            },
            {
                bits: "4"
                name: pde
                desc: '''
                     active high weak pull-down enable
                '''
                swaccess: "rw"
                hwaccess: "hro"
                resval: "0"
            },
            {
                bits: "5"
                name: pp_odrain_selector
                desc: '''
                      Push-pull /Open Drain select pin 
                '''
                swaccess: "rw"
                hwaccess: "hro"
                resval: "1"
            },
            {
                bits: "6"
                name: pudis
                desc: '''
                     Active high disable weak pull-up
                '''
                swaccess: "rw"
                hwaccess: "hro"
                resval: "1"
            },
            {
                bits: "7"
                name: rxdis
                desc: '''
                     active high Disable receiver
                '''
                swaccess: "rw"
                hwaccess: "hro"
                resval: "0"
            },
            {
                bits: "8"
                name: slw_pgm
                desc: '''
                      Slew programmability
                '''
                swaccess: "rw"
                hwaccess: "hro"
                resval: "1"
            },
            {
                bits: "9"
                name: trie
                desc: '''
                      Active high tri-state enable 
                '''
                swaccess: "rw"
                hwaccess: "hro"
                resval: "1"
            },
          ]
      }

       {
          name: PERIPH_12_MUX_SEL
          desc: '''
              Pad signal port multiplex selection for pad periph_12. The programmed value defines which port
              is connected to the pad.
          '''
          swaccess: "rw"
          hwaccess: "hro"
          resval: 1
          fields: [
              {
                  bits: "0:0"
                  enum: [
                      { value: "0", name: "register", desc: "Connects the Pad to the internal configuration register."}
                      { value: "1", name: "port_ethernet_eth_rxctl", desc: "Connect port eth_rxctl from port group ethernet to this pad." }
                  ]
              }
          ]
      }

      {
          name: PERIPH_13_CFG
          desc: '''
            Pad signal configuration.
          '''
          swaccess: "rw"
          fields: [
            {
                bits: "0"
                name: chip2pad
                desc: '''
                     Data input pin from core
                '''
                swaccess: "rw"
                hwaccess: "hro"
                resval: "0"
            },
            {
                bits: "1"
                name: drv0
                desc: '''
                     Drive strength configuration bit 0 (LSB) 
                '''
                swaccess: "rw"
                hwaccess: "hro"
                resval: "1"
            },
            {
                bits: "2"
                name: drv1
                desc: '''
                     Drive strength configuration bit 1 
                '''
                swaccess: "rw"
                hwaccess: "hro"
                resval: "1"
            },
            {
                bits: "3"
                name: drv2
                desc: '''
                     Drive strength configuration bit 2 (MSB) 
                '''
                swaccess: "rw"
                hwaccess: "hro"
                resval: "1"
            },
            {
                bits: "4"
                name: pde
                desc: '''
                     active high weak pull-down enable
                '''
                swaccess: "rw"
                hwaccess: "hro"
                resval: "0"
            },
            {
                bits: "5"
                name: pp_odrain_selector
                desc: '''
                      Push-pull /Open Drain select pin 
                '''
                swaccess: "rw"
                hwaccess: "hro"
                resval: "1"
            },
            {
                bits: "6"
                name: pudis
                desc: '''
                     Active high disable weak pull-up
                '''
                swaccess: "rw"
                hwaccess: "hro"
                resval: "1"
            },
            {
                bits: "7"
                name: rxdis
                desc: '''
                     active high Disable receiver
                '''
                swaccess: "rw"
                hwaccess: "hro"
                resval: "0"
            },
            {
                bits: "8"
                name: slw_pgm
                desc: '''
                      Slew programmability
                '''
                swaccess: "rw"
                hwaccess: "hro"
                resval: "1"
            },
            {
                bits: "9"
                name: trie
                desc: '''
                      Active high tri-state enable 
                '''
                swaccess: "rw"
                hwaccess: "hro"
                resval: "1"
            },
          ]
      }

       {
          name: PERIPH_13_MUX_SEL
          desc: '''
              Pad signal port multiplex selection for pad periph_13. The programmed value defines which port
              is connected to the pad.
          '''
          swaccess: "rw"
          hwaccess: "hro"
          resval: 1
          fields: [
              {
                  bits: "0:0"
                  enum: [
                      { value: "0", name: "register", desc: "Connects the Pad to the internal configuration register."}
                      { value: "1", name: "port_ethernet_eth_rxd0", desc: "Connect port eth_rxd0 from port group ethernet to this pad." }
                  ]
              }
          ]
      }

      {
          name: PERIPH_14_CFG
          desc: '''
            Pad signal configuration.
          '''
          swaccess: "rw"
          fields: [
            {
                bits: "0"
                name: chip2pad
                desc: '''
                     Data input pin from core
                '''
                swaccess: "rw"
                hwaccess: "hro"
                resval: "0"
            },
            {
                bits: "1"
                name: drv0
                desc: '''
                     Drive strength configuration bit 0 (LSB) 
                '''
                swaccess: "rw"
                hwaccess: "hro"
                resval: "1"
            },
            {
                bits: "2"
                name: drv1
                desc: '''
                     Drive strength configuration bit 1 
                '''
                swaccess: "rw"
                hwaccess: "hro"
                resval: "1"
            },
            {
                bits: "3"
                name: drv2
                desc: '''
                     Drive strength configuration bit 2 (MSB) 
                '''
                swaccess: "rw"
                hwaccess: "hro"
                resval: "1"
            },
            {
                bits: "4"
                name: pde
                desc: '''
                     active high weak pull-down enable
                '''
                swaccess: "rw"
                hwaccess: "hro"
                resval: "0"
            },
            {
                bits: "5"
                name: pp_odrain_selector
                desc: '''
                      Push-pull /Open Drain select pin 
                '''
                swaccess: "rw"
                hwaccess: "hro"
                resval: "1"
            },
            {
                bits: "6"
                name: pudis
                desc: '''
                     Active high disable weak pull-up
                '''
                swaccess: "rw"
                hwaccess: "hro"
                resval: "1"
            },
            {
                bits: "7"
                name: rxdis
                desc: '''
                     active high Disable receiver
                '''
                swaccess: "rw"
                hwaccess: "hro"
                resval: "0"
            },
            {
                bits: "8"
                name: slw_pgm
                desc: '''
                      Slew programmability
                '''
                swaccess: "rw"
                hwaccess: "hro"
                resval: "1"
            },
            {
                bits: "9"
                name: trie
                desc: '''
                      Active high tri-state enable 
                '''
                swaccess: "rw"
                hwaccess: "hro"
                resval: "1"
            },
          ]
      }

       {
          name: PERIPH_14_MUX_SEL
          desc: '''
              Pad signal port multiplex selection for pad periph_14. The programmed value defines which port
              is connected to the pad.
          '''
          swaccess: "rw"
          hwaccess: "hro"
          resval: 1
          fields: [
              {
                  bits: "0:0"
                  enum: [
                      { value: "0", name: "register", desc: "Connects the Pad to the internal configuration register."}
                      { value: "1", name: "port_ethernet_eth_rxd1", desc: "Connect port eth_rxd1 from port group ethernet to this pad." }
                  ]
              }
          ]
      }

      {
          name: PERIPH_15_CFG
          desc: '''
            Pad signal configuration.
          '''
          swaccess: "rw"
          fields: [
            {
                bits: "0"
                name: chip2pad
                desc: '''
                     Data input pin from core
                '''
                swaccess: "rw"
                hwaccess: "hro"
                resval: "0"
            },
            {
                bits: "1"
                name: drv0
                desc: '''
                     Drive strength configuration bit 0 (LSB) 
                '''
                swaccess: "rw"
                hwaccess: "hro"
                resval: "1"
            },
            {
                bits: "2"
                name: drv1
                desc: '''
                     Drive strength configuration bit 1 
                '''
                swaccess: "rw"
                hwaccess: "hro"
                resval: "1"
            },
            {
                bits: "3"
                name: drv2
                desc: '''
                     Drive strength configuration bit 2 (MSB) 
                '''
                swaccess: "rw"
                hwaccess: "hro"
                resval: "1"
            },
            {
                bits: "4"
                name: pde
                desc: '''
                     active high weak pull-down enable
                '''
                swaccess: "rw"
                hwaccess: "hro"
                resval: "0"
            },
            {
                bits: "5"
                name: pp_odrain_selector
                desc: '''
                      Push-pull /Open Drain select pin 
                '''
                swaccess: "rw"
                hwaccess: "hro"
                resval: "1"
            },
            {
                bits: "6"
                name: pudis
                desc: '''
                     Active high disable weak pull-up
                '''
                swaccess: "rw"
                hwaccess: "hro"
                resval: "1"
            },
            {
                bits: "7"
                name: rxdis
                desc: '''
                     active high Disable receiver
                '''
                swaccess: "rw"
                hwaccess: "hro"
                resval: "0"
            },
            {
                bits: "8"
                name: slw_pgm
                desc: '''
                      Slew programmability
                '''
                swaccess: "rw"
                hwaccess: "hro"
                resval: "1"
            },
            {
                bits: "9"
                name: trie
                desc: '''
                      Active high tri-state enable 
                '''
                swaccess: "rw"
                hwaccess: "hro"
                resval: "1"
            },
          ]
      }

       {
          name: PERIPH_15_MUX_SEL
          desc: '''
              Pad signal port multiplex selection for pad periph_15. The programmed value defines which port
              is connected to the pad.
          '''
          swaccess: "rw"
          hwaccess: "hro"
          resval: 1
          fields: [
              {
                  bits: "0:0"
                  enum: [
                      { value: "0", name: "register", desc: "Connects the Pad to the internal configuration register."}
                      { value: "1", name: "port_ethernet_eth_rxd2", desc: "Connect port eth_rxd2 from port group ethernet to this pad." }
                  ]
              }
          ]
      }

      {
          name: PERIPH_16_CFG
          desc: '''
            Pad signal configuration.
          '''
          swaccess: "rw"
          fields: [
            {
                bits: "0"
                name: chip2pad
                desc: '''
                     Data input pin from core
                '''
                swaccess: "rw"
                hwaccess: "hro"
                resval: "0"
            },
            {
                bits: "1"
                name: drv0
                desc: '''
                     Drive strength configuration bit 0 (LSB) 
                '''
                swaccess: "rw"
                hwaccess: "hro"
                resval: "1"
            },
            {
                bits: "2"
                name: drv1
                desc: '''
                     Drive strength configuration bit 1 
                '''
                swaccess: "rw"
                hwaccess: "hro"
                resval: "1"
            },
            {
                bits: "3"
                name: drv2
                desc: '''
                     Drive strength configuration bit 2 (MSB) 
                '''
                swaccess: "rw"
                hwaccess: "hro"
                resval: "1"
            },
            {
                bits: "4"
                name: pde
                desc: '''
                     active high weak pull-down enable
                '''
                swaccess: "rw"
                hwaccess: "hro"
                resval: "0"
            },
            {
                bits: "5"
                name: pp_odrain_selector
                desc: '''
                      Push-pull /Open Drain select pin 
                '''
                swaccess: "rw"
                hwaccess: "hro"
                resval: "1"
            },
            {
                bits: "6"
                name: pudis
                desc: '''
                     Active high disable weak pull-up
                '''
                swaccess: "rw"
                hwaccess: "hro"
                resval: "1"
            },
            {
                bits: "7"
                name: rxdis
                desc: '''
                     active high Disable receiver
                '''
                swaccess: "rw"
                hwaccess: "hro"
                resval: "0"
            },
            {
                bits: "8"
                name: slw_pgm
                desc: '''
                      Slew programmability
                '''
                swaccess: "rw"
                hwaccess: "hro"
                resval: "1"
            },
            {
                bits: "9"
                name: trie
                desc: '''
                      Active high tri-state enable 
                '''
                swaccess: "rw"
                hwaccess: "hro"
                resval: "1"
            },
          ]
      }

       {
          name: PERIPH_16_MUX_SEL
          desc: '''
              Pad signal port multiplex selection for pad periph_16. The programmed value defines which port
              is connected to the pad.
          '''
          swaccess: "rw"
          hwaccess: "hro"
          resval: 1
          fields: [
              {
                  bits: "0:0"
                  enum: [
                      { value: "0", name: "register", desc: "Connects the Pad to the internal configuration register."}
                      { value: "1", name: "port_ethernet_eth_rxd3", desc: "Connect port eth_rxd3 from port group ethernet to this pad." }
                  ]
              }
          ]
      }















































      {
          name: DEBUG_OUT0_CFG
          desc: '''
            Pad signal configuration.
          '''
          swaccess: "rw"
          fields: [
            {
                bits: "0"
                name: chip2pad
                desc: '''
                     Data input pin from core
                '''
                swaccess: "rw"
                hwaccess: "hro"
                resval: "0"
            },
            {
                bits: "1"
                name: drv0
                desc: '''
                     Drive strength configuration bit 0 (LSB) 
                '''
                swaccess: "rw"
                hwaccess: "hro"
                resval: "1"
            },
            {
                bits: "2"
                name: drv1
                desc: '''
                     Drive strength configuration bit 1 
                '''
                swaccess: "rw"
                hwaccess: "hro"
                resval: "1"
            },
            {
                bits: "3"
                name: drv2
                desc: '''
                     Drive strength configuration bit 2 (MSB) 
                '''
                swaccess: "rw"
                hwaccess: "hro"
                resval: "1"
            },
            {
                bits: "4"
                name: pde
                desc: '''
                     active high weak pull-down enable
                '''
                swaccess: "rw"
                hwaccess: "hro"
                resval: "0"
            },
            {
                bits: "5"
                name: pp_odrain_selector
                desc: '''
                      Push-pull /Open Drain select pin 
                '''
                swaccess: "rw"
                hwaccess: "hro"
                resval: "1"
            },
            {
                bits: "6"
                name: pudis
                desc: '''
                     Active high disable weak pull-up
                '''
                swaccess: "rw"
                hwaccess: "hro"
                resval: "1"
            },
            {
                bits: "7"
                name: rxdis
                desc: '''
                     active high Disable receiver
                '''
                swaccess: "rw"
                hwaccess: "hro"
                resval: "0"
            },
            {
                bits: "8"
                name: slw_pgm
                desc: '''
                      Slew programmability
                '''
                swaccess: "rw"
                hwaccess: "hro"
                resval: "1"
            },
            {
                bits: "9"
                name: trie
                desc: '''
                      Active high tri-state enable 
                '''
                swaccess: "rw"
                hwaccess: "hro"
                resval: "1"
            },
          ]
      }

       {
          name: DEBUG_OUT0_MUX_SEL
          desc: '''
              Pad signal port multiplex selection for pad debug_out0. The programmed value defines which port
              is connected to the pad.
          '''
          swaccess: "rw"
          hwaccess: "hro"
          resval: 4
          fields: [
              {
                  bits: "4:0"
                  enum: [
                      { value: "0", name: "register", desc: "Connects the Pad to the internal configuration register."}
                      { value: "1", name: "port_debug_signals_alt_clk", desc: "Connect port alt_clk from port group debug_signals to this pad." }
                      { value: "2", name: "port_debug_signals_alt_pll", desc: "Connect port alt_pll from port group debug_signals to this pad." }
                      { value: "3", name: "port_debug_signals_host_clk", desc: "Connect port host_clk from port group debug_signals to this pad." }
                      { value: "4", name: "port_debug_signals_host_pll", desc: "Connect port host_pll from port group debug_signals to this pad." }
                      { value: "5", name: "port_debug_signals_host_por_n", desc: "Connect port host_por_n from port group debug_signals to this pad." }
                      { value: "6", name: "port_debug_signals_periph_clk", desc: "Connect port periph_clk from port group debug_signals to this pad." }
                      { value: "7", name: "port_debug_signals_periph_domain_clk", desc: "Connect port periph_domain_clk from port group debug_signals to this pad." }
                      { value: "8", name: "port_debug_signals_periph_domain_rstn", desc: "Connect port periph_domain_rstn from port group debug_signals to this pad." }
                      { value: "9", name: "port_debug_signals_periph_pll", desc: "Connect port periph_pll from port group debug_signals to this pad." }
                      { value: "10", name: "port_debug_signals_pulp_cluster_domain_clk", desc: "Connect port pulp_cluster_domain_clk from port group debug_signals to this pad." }
                      { value: "11", name: "port_debug_signals_pulp_cluster_domain_rstn", desc: "Connect port pulp_cluster_domain_rstn from port group debug_signals to this pad." }
                      { value: "12", name: "port_debug_signals_safety_island_domain_clk", desc: "Connect port safety_island_domain_clk from port group debug_signals to this pad." }
                      { value: "13", name: "port_debug_signals_safety_island_domain_rstn", desc: "Connect port safety_island_domain_rstn from port group debug_signals to this pad." }
                      { value: "14", name: "port_debug_signals_security_island_domain_clk", desc: "Connect port security_island_domain_clk from port group debug_signals to this pad." }
                      { value: "15", name: "port_debug_signals_security_island_domain_rstn", desc: "Connect port security_island_domain_rstn from port group debug_signals to this pad." }
                      { value: "16", name: "port_debug_signals_spatz_cluster_domain_clk", desc: "Connect port spatz_cluster_domain_clk from port group debug_signals to this pad." }
                      { value: "17", name: "port_debug_signals_spatz_cluster_domain_rstn", desc: "Connect port spatz_cluster_domain_rstn from port group debug_signals to this pad." }
                  ]
              }
          ]
      }

      {
          name: DEBUG_OUT1_CFG
          desc: '''
            Pad signal configuration.
          '''
          swaccess: "rw"
          fields: [
            {
                bits: "0"
                name: chip2pad
                desc: '''
                     Data input pin from core
                '''
                swaccess: "rw"
                hwaccess: "hro"
                resval: "0"
            },
            {
                bits: "1"
                name: drv0
                desc: '''
                     Drive strength configuration bit 0 (LSB) 
                '''
                swaccess: "rw"
                hwaccess: "hro"
                resval: "1"
            },
            {
                bits: "2"
                name: drv1
                desc: '''
                     Drive strength configuration bit 1 
                '''
                swaccess: "rw"
                hwaccess: "hro"
                resval: "1"
            },
            {
                bits: "3"
                name: drv2
                desc: '''
                     Drive strength configuration bit 2 (MSB) 
                '''
                swaccess: "rw"
                hwaccess: "hro"
                resval: "1"
            },
            {
                bits: "4"
                name: pde
                desc: '''
                     active high weak pull-down enable
                '''
                swaccess: "rw"
                hwaccess: "hro"
                resval: "0"
            },
            {
                bits: "5"
                name: pp_odrain_selector
                desc: '''
                      Push-pull /Open Drain select pin 
                '''
                swaccess: "rw"
                hwaccess: "hro"
                resval: "1"
            },
            {
                bits: "6"
                name: pudis
                desc: '''
                     Active high disable weak pull-up
                '''
                swaccess: "rw"
                hwaccess: "hro"
                resval: "1"
            },
            {
                bits: "7"
                name: rxdis
                desc: '''
                     active high Disable receiver
                '''
                swaccess: "rw"
                hwaccess: "hro"
                resval: "0"
            },
            {
                bits: "8"
                name: slw_pgm
                desc: '''
                      Slew programmability
                '''
                swaccess: "rw"
                hwaccess: "hro"
                resval: "1"
            },
            {
                bits: "9"
                name: trie
                desc: '''
                      Active high tri-state enable 
                '''
                swaccess: "rw"
                hwaccess: "hro"
                resval: "1"
            },
          ]
      }

       {
          name: DEBUG_OUT1_MUX_SEL
          desc: '''
              Pad signal port multiplex selection for pad debug_out1. The programmed value defines which port
              is connected to the pad.
          '''
          swaccess: "rw"
          hwaccess: "hro"
          resval: 2
          fields: [
              {
                  bits: "4:0"
                  enum: [
                      { value: "0", name: "register", desc: "Connects the Pad to the internal configuration register."}
                      { value: "1", name: "port_debug_signals_alt_clk", desc: "Connect port alt_clk from port group debug_signals to this pad." }
                      { value: "2", name: "port_debug_signals_alt_pll", desc: "Connect port alt_pll from port group debug_signals to this pad." }
                      { value: "3", name: "port_debug_signals_host_clk", desc: "Connect port host_clk from port group debug_signals to this pad." }
                      { value: "4", name: "port_debug_signals_host_pll", desc: "Connect port host_pll from port group debug_signals to this pad." }
                      { value: "5", name: "port_debug_signals_host_por_n", desc: "Connect port host_por_n from port group debug_signals to this pad." }
                      { value: "6", name: "port_debug_signals_periph_clk", desc: "Connect port periph_clk from port group debug_signals to this pad." }
                      { value: "7", name: "port_debug_signals_periph_domain_clk", desc: "Connect port periph_domain_clk from port group debug_signals to this pad." }
                      { value: "8", name: "port_debug_signals_periph_domain_rstn", desc: "Connect port periph_domain_rstn from port group debug_signals to this pad." }
                      { value: "9", name: "port_debug_signals_periph_pll", desc: "Connect port periph_pll from port group debug_signals to this pad." }
                      { value: "10", name: "port_debug_signals_pulp_cluster_domain_clk", desc: "Connect port pulp_cluster_domain_clk from port group debug_signals to this pad." }
                      { value: "11", name: "port_debug_signals_pulp_cluster_domain_rstn", desc: "Connect port pulp_cluster_domain_rstn from port group debug_signals to this pad." }
                      { value: "12", name: "port_debug_signals_safety_island_domain_clk", desc: "Connect port safety_island_domain_clk from port group debug_signals to this pad." }
                      { value: "13", name: "port_debug_signals_safety_island_domain_rstn", desc: "Connect port safety_island_domain_rstn from port group debug_signals to this pad." }
                      { value: "14", name: "port_debug_signals_security_island_domain_clk", desc: "Connect port security_island_domain_clk from port group debug_signals to this pad." }
                      { value: "15", name: "port_debug_signals_security_island_domain_rstn", desc: "Connect port security_island_domain_rstn from port group debug_signals to this pad." }
                      { value: "16", name: "port_debug_signals_spatz_cluster_domain_clk", desc: "Connect port spatz_cluster_domain_clk from port group debug_signals to this pad." }
                      { value: "17", name: "port_debug_signals_spatz_cluster_domain_rstn", desc: "Connect port spatz_cluster_domain_rstn from port group debug_signals to this pad." }
                  ]
              }
          ]
      }

      {
          name: DEBUG_OUT2_CFG
          desc: '''
            Pad signal configuration.
          '''
          swaccess: "rw"
          fields: [
            {
                bits: "0"
                name: chip2pad
                desc: '''
                     Data input pin from core
                '''
                swaccess: "rw"
                hwaccess: "hro"
                resval: "0"
            },
            {
                bits: "1"
                name: drv0
                desc: '''
                     Drive strength configuration bit 0 (LSB) 
                '''
                swaccess: "rw"
                hwaccess: "hro"
                resval: "1"
            },
            {
                bits: "2"
                name: drv1
                desc: '''
                     Drive strength configuration bit 1 
                '''
                swaccess: "rw"
                hwaccess: "hro"
                resval: "1"
            },
            {
                bits: "3"
                name: drv2
                desc: '''
                     Drive strength configuration bit 2 (MSB) 
                '''
                swaccess: "rw"
                hwaccess: "hro"
                resval: "1"
            },
            {
                bits: "4"
                name: pde
                desc: '''
                     active high weak pull-down enable
                '''
                swaccess: "rw"
                hwaccess: "hro"
                resval: "0"
            },
            {
                bits: "5"
                name: pp_odrain_selector
                desc: '''
                      Push-pull /Open Drain select pin 
                '''
                swaccess: "rw"
                hwaccess: "hro"
                resval: "1"
            },
            {
                bits: "6"
                name: pudis
                desc: '''
                     Active high disable weak pull-up
                '''
                swaccess: "rw"
                hwaccess: "hro"
                resval: "1"
            },
            {
                bits: "7"
                name: rxdis
                desc: '''
                     active high Disable receiver
                '''
                swaccess: "rw"
                hwaccess: "hro"
                resval: "0"
            },
            {
                bits: "8"
                name: slw_pgm
                desc: '''
                      Slew programmability
                '''
                swaccess: "rw"
                hwaccess: "hro"
                resval: "1"
            },
            {
                bits: "9"
                name: trie
                desc: '''
                      Active high tri-state enable 
                '''
                swaccess: "rw"
                hwaccess: "hro"
                resval: "1"
            },
          ]
      }

       {
          name: DEBUG_OUT2_MUX_SEL
          desc: '''
              Pad signal port multiplex selection for pad debug_out2. The programmed value defines which port
              is connected to the pad.
          '''
          swaccess: "rw"
          hwaccess: "hro"
          resval: 9
          fields: [
              {
                  bits: "4:0"
                  enum: [
                      { value: "0", name: "register", desc: "Connects the Pad to the internal configuration register."}
                      { value: "1", name: "port_debug_signals_alt_clk", desc: "Connect port alt_clk from port group debug_signals to this pad." }
                      { value: "2", name: "port_debug_signals_alt_pll", desc: "Connect port alt_pll from port group debug_signals to this pad." }
                      { value: "3", name: "port_debug_signals_host_clk", desc: "Connect port host_clk from port group debug_signals to this pad." }
                      { value: "4", name: "port_debug_signals_host_pll", desc: "Connect port host_pll from port group debug_signals to this pad." }
                      { value: "5", name: "port_debug_signals_host_por_n", desc: "Connect port host_por_n from port group debug_signals to this pad." }
                      { value: "6", name: "port_debug_signals_periph_clk", desc: "Connect port periph_clk from port group debug_signals to this pad." }
                      { value: "7", name: "port_debug_signals_periph_domain_clk", desc: "Connect port periph_domain_clk from port group debug_signals to this pad." }
                      { value: "8", name: "port_debug_signals_periph_domain_rstn", desc: "Connect port periph_domain_rstn from port group debug_signals to this pad." }
                      { value: "9", name: "port_debug_signals_periph_pll", desc: "Connect port periph_pll from port group debug_signals to this pad." }
                      { value: "10", name: "port_debug_signals_pulp_cluster_domain_clk", desc: "Connect port pulp_cluster_domain_clk from port group debug_signals to this pad." }
                      { value: "11", name: "port_debug_signals_pulp_cluster_domain_rstn", desc: "Connect port pulp_cluster_domain_rstn from port group debug_signals to this pad." }
                      { value: "12", name: "port_debug_signals_safety_island_domain_clk", desc: "Connect port safety_island_domain_clk from port group debug_signals to this pad." }
                      { value: "13", name: "port_debug_signals_safety_island_domain_rstn", desc: "Connect port safety_island_domain_rstn from port group debug_signals to this pad." }
                      { value: "14", name: "port_debug_signals_security_island_domain_clk", desc: "Connect port security_island_domain_clk from port group debug_signals to this pad." }
                      { value: "15", name: "port_debug_signals_security_island_domain_rstn", desc: "Connect port security_island_domain_rstn from port group debug_signals to this pad." }
                      { value: "16", name: "port_debug_signals_spatz_cluster_domain_clk", desc: "Connect port spatz_cluster_domain_clk from port group debug_signals to this pad." }
                      { value: "17", name: "port_debug_signals_spatz_cluster_domain_rstn", desc: "Connect port spatz_cluster_domain_rstn from port group debug_signals to this pad." }
                  ]
              }
          ]
      }

      {
          name: DEBUG_OUT3_CFG
          desc: '''
            Pad signal configuration.
          '''
          swaccess: "rw"
          fields: [
            {
                bits: "0"
                name: chip2pad
                desc: '''
                     Data input pin from core
                '''
                swaccess: "rw"
                hwaccess: "hro"
                resval: "0"
            },
            {
                bits: "1"
                name: drv0
                desc: '''
                     Drive strength configuration bit 0 (LSB) 
                '''
                swaccess: "rw"
                hwaccess: "hro"
                resval: "1"
            },
            {
                bits: "2"
                name: drv1
                desc: '''
                     Drive strength configuration bit 1 
                '''
                swaccess: "rw"
                hwaccess: "hro"
                resval: "1"
            },
            {
                bits: "3"
                name: drv2
                desc: '''
                     Drive strength configuration bit 2 (MSB) 
                '''
                swaccess: "rw"
                hwaccess: "hro"
                resval: "1"
            },
            {
                bits: "4"
                name: pde
                desc: '''
                     active high weak pull-down enable
                '''
                swaccess: "rw"
                hwaccess: "hro"
                resval: "0"
            },
            {
                bits: "5"
                name: pp_odrain_selector
                desc: '''
                      Push-pull /Open Drain select pin 
                '''
                swaccess: "rw"
                hwaccess: "hro"
                resval: "1"
            },
            {
                bits: "6"
                name: pudis
                desc: '''
                     Active high disable weak pull-up
                '''
                swaccess: "rw"
                hwaccess: "hro"
                resval: "1"
            },
            {
                bits: "7"
                name: rxdis
                desc: '''
                     active high Disable receiver
                '''
                swaccess: "rw"
                hwaccess: "hro"
                resval: "0"
            },
            {
                bits: "8"
                name: slw_pgm
                desc: '''
                      Slew programmability
                '''
                swaccess: "rw"
                hwaccess: "hro"
                resval: "1"
            },
            {
                bits: "9"
                name: trie
                desc: '''
                      Active high tri-state enable 
                '''
                swaccess: "rw"
                hwaccess: "hro"
                resval: "1"
            },
          ]
      }

       {
          name: DEBUG_OUT3_MUX_SEL
          desc: '''
              Pad signal port multiplex selection for pad debug_out3. The programmed value defines which port
              is connected to the pad.
          '''
          swaccess: "rw"
          hwaccess: "hro"
          resval: 3
          fields: [
              {
                  bits: "4:0"
                  enum: [
                      { value: "0", name: "register", desc: "Connects the Pad to the internal configuration register."}
                      { value: "1", name: "port_debug_signals_alt_clk", desc: "Connect port alt_clk from port group debug_signals to this pad." }
                      { value: "2", name: "port_debug_signals_alt_pll", desc: "Connect port alt_pll from port group debug_signals to this pad." }
                      { value: "3", name: "port_debug_signals_host_clk", desc: "Connect port host_clk from port group debug_signals to this pad." }
                      { value: "4", name: "port_debug_signals_host_pll", desc: "Connect port host_pll from port group debug_signals to this pad." }
                      { value: "5", name: "port_debug_signals_host_por_n", desc: "Connect port host_por_n from port group debug_signals to this pad." }
                      { value: "6", name: "port_debug_signals_periph_clk", desc: "Connect port periph_clk from port group debug_signals to this pad." }
                      { value: "7", name: "port_debug_signals_periph_domain_clk", desc: "Connect port periph_domain_clk from port group debug_signals to this pad." }
                      { value: "8", name: "port_debug_signals_periph_domain_rstn", desc: "Connect port periph_domain_rstn from port group debug_signals to this pad." }
                      { value: "9", name: "port_debug_signals_periph_pll", desc: "Connect port periph_pll from port group debug_signals to this pad." }
                      { value: "10", name: "port_debug_signals_pulp_cluster_domain_clk", desc: "Connect port pulp_cluster_domain_clk from port group debug_signals to this pad." }
                      { value: "11", name: "port_debug_signals_pulp_cluster_domain_rstn", desc: "Connect port pulp_cluster_domain_rstn from port group debug_signals to this pad." }
                      { value: "12", name: "port_debug_signals_safety_island_domain_clk", desc: "Connect port safety_island_domain_clk from port group debug_signals to this pad." }
                      { value: "13", name: "port_debug_signals_safety_island_domain_rstn", desc: "Connect port safety_island_domain_rstn from port group debug_signals to this pad." }
                      { value: "14", name: "port_debug_signals_security_island_domain_clk", desc: "Connect port security_island_domain_clk from port group debug_signals to this pad." }
                      { value: "15", name: "port_debug_signals_security_island_domain_rstn", desc: "Connect port security_island_domain_rstn from port group debug_signals to this pad." }
                      { value: "16", name: "port_debug_signals_spatz_cluster_domain_clk", desc: "Connect port spatz_cluster_domain_clk from port group debug_signals to this pad." }
                      { value: "17", name: "port_debug_signals_spatz_cluster_domain_rstn", desc: "Connect port spatz_cluster_domain_rstn from port group debug_signals to this pad." }
                  ]
              }
          ]
      }

      {
          name: DEBUG_OUT4_CFG
          desc: '''
            Pad signal configuration.
          '''
          swaccess: "rw"
          fields: [
            {
                bits: "0"
                name: chip2pad
                desc: '''
                     Data input pin from core
                '''
                swaccess: "rw"
                hwaccess: "hro"
                resval: "0"
            },
            {
                bits: "1"
                name: drv0
                desc: '''
                     Drive strength configuration bit 0 (LSB) 
                '''
                swaccess: "rw"
                hwaccess: "hro"
                resval: "1"
            },
            {
                bits: "2"
                name: drv1
                desc: '''
                     Drive strength configuration bit 1 
                '''
                swaccess: "rw"
                hwaccess: "hro"
                resval: "1"
            },
            {
                bits: "3"
                name: drv2
                desc: '''
                     Drive strength configuration bit 2 (MSB) 
                '''
                swaccess: "rw"
                hwaccess: "hro"
                resval: "1"
            },
            {
                bits: "4"
                name: pde
                desc: '''
                     active high weak pull-down enable
                '''
                swaccess: "rw"
                hwaccess: "hro"
                resval: "0"
            },
            {
                bits: "5"
                name: pp_odrain_selector
                desc: '''
                      Push-pull /Open Drain select pin 
                '''
                swaccess: "rw"
                hwaccess: "hro"
                resval: "1"
            },
            {
                bits: "6"
                name: pudis
                desc: '''
                     Active high disable weak pull-up
                '''
                swaccess: "rw"
                hwaccess: "hro"
                resval: "1"
            },
            {
                bits: "7"
                name: rxdis
                desc: '''
                     active high Disable receiver
                '''
                swaccess: "rw"
                hwaccess: "hro"
                resval: "0"
            },
            {
                bits: "8"
                name: slw_pgm
                desc: '''
                      Slew programmability
                '''
                swaccess: "rw"
                hwaccess: "hro"
                resval: "1"
            },
            {
                bits: "9"
                name: trie
                desc: '''
                      Active high tri-state enable 
                '''
                swaccess: "rw"
                hwaccess: "hro"
                resval: "1"
            },
          ]
      }

       {
          name: DEBUG_OUT4_MUX_SEL
          desc: '''
              Pad signal port multiplex selection for pad debug_out4. The programmed value defines which port
              is connected to the pad.
          '''
          swaccess: "rw"
          hwaccess: "hro"
          resval: 5
          fields: [
              {
                  bits: "4:0"
                  enum: [
                      { value: "0", name: "register", desc: "Connects the Pad to the internal configuration register."}
                      { value: "1", name: "port_debug_signals_alt_clk", desc: "Connect port alt_clk from port group debug_signals to this pad." }
                      { value: "2", name: "port_debug_signals_alt_pll", desc: "Connect port alt_pll from port group debug_signals to this pad." }
                      { value: "3", name: "port_debug_signals_host_clk", desc: "Connect port host_clk from port group debug_signals to this pad." }
                      { value: "4", name: "port_debug_signals_host_pll", desc: "Connect port host_pll from port group debug_signals to this pad." }
                      { value: "5", name: "port_debug_signals_host_por_n", desc: "Connect port host_por_n from port group debug_signals to this pad." }
                      { value: "6", name: "port_debug_signals_periph_clk", desc: "Connect port periph_clk from port group debug_signals to this pad." }
                      { value: "7", name: "port_debug_signals_periph_domain_clk", desc: "Connect port periph_domain_clk from port group debug_signals to this pad." }
                      { value: "8", name: "port_debug_signals_periph_domain_rstn", desc: "Connect port periph_domain_rstn from port group debug_signals to this pad." }
                      { value: "9", name: "port_debug_signals_periph_pll", desc: "Connect port periph_pll from port group debug_signals to this pad." }
                      { value: "10", name: "port_debug_signals_pulp_cluster_domain_clk", desc: "Connect port pulp_cluster_domain_clk from port group debug_signals to this pad." }
                      { value: "11", name: "port_debug_signals_pulp_cluster_domain_rstn", desc: "Connect port pulp_cluster_domain_rstn from port group debug_signals to this pad." }
                      { value: "12", name: "port_debug_signals_safety_island_domain_clk", desc: "Connect port safety_island_domain_clk from port group debug_signals to this pad." }
                      { value: "13", name: "port_debug_signals_safety_island_domain_rstn", desc: "Connect port safety_island_domain_rstn from port group debug_signals to this pad." }
                      { value: "14", name: "port_debug_signals_security_island_domain_clk", desc: "Connect port security_island_domain_clk from port group debug_signals to this pad." }
                      { value: "15", name: "port_debug_signals_security_island_domain_rstn", desc: "Connect port security_island_domain_rstn from port group debug_signals to this pad." }
                      { value: "16", name: "port_debug_signals_spatz_cluster_domain_clk", desc: "Connect port spatz_cluster_domain_clk from port group debug_signals to this pad." }
                      { value: "17", name: "port_debug_signals_spatz_cluster_domain_rstn", desc: "Connect port spatz_cluster_domain_rstn from port group debug_signals to this pad." }
                  ]
              }
          ]
      }

      {
          name: JTAG_PLL_00_CFG
          desc: '''
            Pad signal configuration.
          '''
          swaccess: "rw"
          fields: [
            {
                bits: "0"
                name: chip2pad
                desc: '''
                     Data input pin from core
                '''
                swaccess: "rw"
                hwaccess: "hro"
                resval: "0"
            },
            {
                bits: "1"
                name: drv0
                desc: '''
                     Drive strength configuration bit 0 (LSB) 
                '''
                swaccess: "rw"
                hwaccess: "hro"
                resval: "1"
            },
            {
                bits: "2"
                name: drv1
                desc: '''
                     Drive strength configuration bit 1 
                '''
                swaccess: "rw"
                hwaccess: "hro"
                resval: "1"
            },
            {
                bits: "3"
                name: drv2
                desc: '''
                     Drive strength configuration bit 2 (MSB) 
                '''
                swaccess: "rw"
                hwaccess: "hro"
                resval: "1"
            },
            {
                bits: "4"
                name: pde
                desc: '''
                     active high weak pull-down enable
                '''
                swaccess: "rw"
                hwaccess: "hro"
                resval: "0"
            },
            {
                bits: "5"
                name: pp_odrain_selector
                desc: '''
                      Push-pull /Open Drain select pin 
                '''
                swaccess: "rw"
                hwaccess: "hro"
                resval: "1"
            },
            {
                bits: "6"
                name: pudis
                desc: '''
                     Active high disable weak pull-up
                '''
                swaccess: "rw"
                hwaccess: "hro"
                resval: "1"
            },
            {
                bits: "7"
                name: rxdis
                desc: '''
                     active high Disable receiver
                '''
                swaccess: "rw"
                hwaccess: "hro"
                resval: "0"
            },
            {
                bits: "8"
                name: slw_pgm
                desc: '''
                      Slew programmability
                '''
                swaccess: "rw"
                hwaccess: "hro"
                resval: "1"
            },
            {
                bits: "9"
                name: trie
                desc: '''
                      Active high tri-state enable 
                '''
                swaccess: "rw"
                hwaccess: "hro"
                resval: "1"
            },
          ]
      }

       {
          name: JTAG_PLL_00_MUX_SEL
          desc: '''
              Pad signal port multiplex selection for pad jtag_pll_00. The programmed value defines which port
              is connected to the pad.
          '''
          swaccess: "rw"
          hwaccess: "hro"
          resval: 1
          fields: [
              {
                  bits: "1:0"
                  enum: [
                      { value: "0", name: "register", desc: "Connects the Pad to the internal configuration register."}
                      { value: "1", name: "port_jtag_pll0_tck", desc: "Connect port tck from port group jtag_pll0 to this pad." }
                      { value: "2", name: "port_jtag_pll1_tck", desc: "Connect port tck from port group jtag_pll1 to this pad." }
                      { value: "3", name: "port_jtag_pll2_tck", desc: "Connect port tck from port group jtag_pll2 to this pad." }
                  ]
              }
          ]
      }

      {
          name: JTAG_PLL_01_CFG
          desc: '''
            Pad signal configuration.
          '''
          swaccess: "rw"
          fields: [
            {
                bits: "0"
                name: chip2pad
                desc: '''
                     Data input pin from core
                '''
                swaccess: "rw"
                hwaccess: "hro"
                resval: "0"
            },
            {
                bits: "1"
                name: drv0
                desc: '''
                     Drive strength configuration bit 0 (LSB) 
                '''
                swaccess: "rw"
                hwaccess: "hro"
                resval: "1"
            },
            {
                bits: "2"
                name: drv1
                desc: '''
                     Drive strength configuration bit 1 
                '''
                swaccess: "rw"
                hwaccess: "hro"
                resval: "1"
            },
            {
                bits: "3"
                name: drv2
                desc: '''
                     Drive strength configuration bit 2 (MSB) 
                '''
                swaccess: "rw"
                hwaccess: "hro"
                resval: "1"
            },
            {
                bits: "4"
                name: pde
                desc: '''
                     active high weak pull-down enable
                '''
                swaccess: "rw"
                hwaccess: "hro"
                resval: "0"
            },
            {
                bits: "5"
                name: pp_odrain_selector
                desc: '''
                      Push-pull /Open Drain select pin 
                '''
                swaccess: "rw"
                hwaccess: "hro"
                resval: "1"
            },
            {
                bits: "6"
                name: pudis
                desc: '''
                     Active high disable weak pull-up
                '''
                swaccess: "rw"
                hwaccess: "hro"
                resval: "1"
            },
            {
                bits: "7"
                name: rxdis
                desc: '''
                     active high Disable receiver
                '''
                swaccess: "rw"
                hwaccess: "hro"
                resval: "0"
            },
            {
                bits: "8"
                name: slw_pgm
                desc: '''
                      Slew programmability
                '''
                swaccess: "rw"
                hwaccess: "hro"
                resval: "1"
            },
            {
                bits: "9"
                name: trie
                desc: '''
                      Active high tri-state enable 
                '''
                swaccess: "rw"
                hwaccess: "hro"
                resval: "1"
            },
          ]
      }

       {
          name: JTAG_PLL_01_MUX_SEL
          desc: '''
              Pad signal port multiplex selection for pad jtag_pll_01. The programmed value defines which port
              is connected to the pad.
          '''
          swaccess: "rw"
          hwaccess: "hro"
          resval: 1
          fields: [
              {
                  bits: "1:0"
                  enum: [
                      { value: "0", name: "register", desc: "Connects the Pad to the internal configuration register."}
                      { value: "1", name: "port_jtag_pll0_tms", desc: "Connect port tms from port group jtag_pll0 to this pad." }
                      { value: "2", name: "port_jtag_pll1_tms", desc: "Connect port tms from port group jtag_pll1 to this pad." }
                      { value: "3", name: "port_jtag_pll2_tms", desc: "Connect port tms from port group jtag_pll2 to this pad." }
                  ]
              }
          ]
      }

      {
          name: JTAG_PLL_02_CFG
          desc: '''
            Pad signal configuration.
          '''
          swaccess: "rw"
          fields: [
            {
                bits: "0"
                name: chip2pad
                desc: '''
                     Data input pin from core
                '''
                swaccess: "rw"
                hwaccess: "hro"
                resval: "0"
            },
            {
                bits: "1"
                name: drv0
                desc: '''
                     Drive strength configuration bit 0 (LSB) 
                '''
                swaccess: "rw"
                hwaccess: "hro"
                resval: "1"
            },
            {
                bits: "2"
                name: drv1
                desc: '''
                     Drive strength configuration bit 1 
                '''
                swaccess: "rw"
                hwaccess: "hro"
                resval: "1"
            },
            {
                bits: "3"
                name: drv2
                desc: '''
                     Drive strength configuration bit 2 (MSB) 
                '''
                swaccess: "rw"
                hwaccess: "hro"
                resval: "1"
            },
            {
                bits: "4"
                name: pde
                desc: '''
                     active high weak pull-down enable
                '''
                swaccess: "rw"
                hwaccess: "hro"
                resval: "0"
            },
            {
                bits: "5"
                name: pp_odrain_selector
                desc: '''
                      Push-pull /Open Drain select pin 
                '''
                swaccess: "rw"
                hwaccess: "hro"
                resval: "1"
            },
            {
                bits: "6"
                name: pudis
                desc: '''
                     Active high disable weak pull-up
                '''
                swaccess: "rw"
                hwaccess: "hro"
                resval: "1"
            },
            {
                bits: "7"
                name: rxdis
                desc: '''
                     active high Disable receiver
                '''
                swaccess: "rw"
                hwaccess: "hro"
                resval: "0"
            },
            {
                bits: "8"
                name: slw_pgm
                desc: '''
                      Slew programmability
                '''
                swaccess: "rw"
                hwaccess: "hro"
                resval: "1"
            },
            {
                bits: "9"
                name: trie
                desc: '''
                      Active high tri-state enable 
                '''
                swaccess: "rw"
                hwaccess: "hro"
                resval: "1"
            },
          ]
      }

       {
          name: JTAG_PLL_02_MUX_SEL
          desc: '''
              Pad signal port multiplex selection for pad jtag_pll_02. The programmed value defines which port
              is connected to the pad.
          '''
          swaccess: "rw"
          hwaccess: "hro"
          resval: 1
          fields: [
              {
                  bits: "1:0"
                  enum: [
                      { value: "0", name: "register", desc: "Connects the Pad to the internal configuration register."}
                      { value: "1", name: "port_jtag_pll0_tdi", desc: "Connect port tdi from port group jtag_pll0 to this pad." }
                      { value: "2", name: "port_jtag_pll1_tdi", desc: "Connect port tdi from port group jtag_pll1 to this pad." }
                      { value: "3", name: "port_jtag_pll2_tdi", desc: "Connect port tdi from port group jtag_pll2 to this pad." }
                  ]
              }
          ]
      }

      {
          name: JTAG_PLL_03_CFG
          desc: '''
            Pad signal configuration.
          '''
          swaccess: "rw"
          fields: [
            {
                bits: "0"
                name: chip2pad
                desc: '''
                     Data input pin from core
                '''
                swaccess: "rw"
                hwaccess: "hro"
                resval: "0"
            },
            {
                bits: "1"
                name: drv0
                desc: '''
                     Drive strength configuration bit 0 (LSB) 
                '''
                swaccess: "rw"
                hwaccess: "hro"
                resval: "1"
            },
            {
                bits: "2"
                name: drv1
                desc: '''
                     Drive strength configuration bit 1 
                '''
                swaccess: "rw"
                hwaccess: "hro"
                resval: "1"
            },
            {
                bits: "3"
                name: drv2
                desc: '''
                     Drive strength configuration bit 2 (MSB) 
                '''
                swaccess: "rw"
                hwaccess: "hro"
                resval: "1"
            },
            {
                bits: "4"
                name: pde
                desc: '''
                     active high weak pull-down enable
                '''
                swaccess: "rw"
                hwaccess: "hro"
                resval: "0"
            },
            {
                bits: "5"
                name: pp_odrain_selector
                desc: '''
                      Push-pull /Open Drain select pin 
                '''
                swaccess: "rw"
                hwaccess: "hro"
                resval: "1"
            },
            {
                bits: "6"
                name: pudis
                desc: '''
                     Active high disable weak pull-up
                '''
                swaccess: "rw"
                hwaccess: "hro"
                resval: "1"
            },
            {
                bits: "7"
                name: rxdis
                desc: '''
                     active high Disable receiver
                '''
                swaccess: "rw"
                hwaccess: "hro"
                resval: "0"
            },
            {
                bits: "8"
                name: slw_pgm
                desc: '''
                      Slew programmability
                '''
                swaccess: "rw"
                hwaccess: "hro"
                resval: "1"
            },
            {
                bits: "9"
                name: trie
                desc: '''
                      Active high tri-state enable 
                '''
                swaccess: "rw"
                hwaccess: "hro"
                resval: "1"
            },
          ]
      }

       {
          name: JTAG_PLL_03_MUX_SEL
          desc: '''
              Pad signal port multiplex selection for pad jtag_pll_03. The programmed value defines which port
              is connected to the pad.
          '''
          swaccess: "rw"
          hwaccess: "hro"
          resval: 1
          fields: [
              {
                  bits: "1:0"
                  enum: [
                      { value: "0", name: "register", desc: "Connects the Pad to the internal configuration register."}
                      { value: "1", name: "port_jtag_pll0_trstn", desc: "Connect port trstn from port group jtag_pll0 to this pad." }
                      { value: "2", name: "port_jtag_pll1_trstn", desc: "Connect port trstn from port group jtag_pll1 to this pad." }
                      { value: "3", name: "port_jtag_pll2_trstn", desc: "Connect port trstn from port group jtag_pll2 to this pad." }
                  ]
              }
          ]
      }

      {
          name: JTAG_PLL_04_CFG
          desc: '''
            Pad signal configuration.
          '''
          swaccess: "rw"
          fields: [
            {
                bits: "0"
                name: chip2pad
                desc: '''
                     Data input pin from core
                '''
                swaccess: "rw"
                hwaccess: "hro"
                resval: "0"
            },
            {
                bits: "1"
                name: drv0
                desc: '''
                     Drive strength configuration bit 0 (LSB) 
                '''
                swaccess: "rw"
                hwaccess: "hro"
                resval: "1"
            },
            {
                bits: "2"
                name: drv1
                desc: '''
                     Drive strength configuration bit 1 
                '''
                swaccess: "rw"
                hwaccess: "hro"
                resval: "1"
            },
            {
                bits: "3"
                name: drv2
                desc: '''
                     Drive strength configuration bit 2 (MSB) 
                '''
                swaccess: "rw"
                hwaccess: "hro"
                resval: "1"
            },
            {
                bits: "4"
                name: pde
                desc: '''
                     active high weak pull-down enable
                '''
                swaccess: "rw"
                hwaccess: "hro"
                resval: "0"
            },
            {
                bits: "5"
                name: pp_odrain_selector
                desc: '''
                      Push-pull /Open Drain select pin 
                '''
                swaccess: "rw"
                hwaccess: "hro"
                resval: "1"
            },
            {
                bits: "6"
                name: pudis
                desc: '''
                     Active high disable weak pull-up
                '''
                swaccess: "rw"
                hwaccess: "hro"
                resval: "1"
            },
            {
                bits: "7"
                name: rxdis
                desc: '''
                     active high Disable receiver
                '''
                swaccess: "rw"
                hwaccess: "hro"
                resval: "0"
            },
            {
                bits: "8"
                name: slw_pgm
                desc: '''
                      Slew programmability
                '''
                swaccess: "rw"
                hwaccess: "hro"
                resval: "1"
            },
            {
                bits: "9"
                name: trie
                desc: '''
                      Active high tri-state enable 
                '''
                swaccess: "rw"
                hwaccess: "hro"
                resval: "1"
            },
          ]
      }

       {
          name: JTAG_PLL_04_MUX_SEL
          desc: '''
              Pad signal port multiplex selection for pad jtag_pll_04. The programmed value defines which port
              is connected to the pad.
          '''
          swaccess: "rw"
          hwaccess: "hro"
          resval: 1
          fields: [
              {
                  bits: "1:0"
                  enum: [
                      { value: "0", name: "register", desc: "Connects the Pad to the internal configuration register."}
                      { value: "1", name: "port_jtag_pll0_tdo", desc: "Connect port tdo from port group jtag_pll0 to this pad." }
                      { value: "2", name: "port_jtag_pll1_tdo", desc: "Connect port tdo from port group jtag_pll1 to this pad." }
                      { value: "3", name: "port_jtag_pll2_tdo", desc: "Connect port tdo from port group jtag_pll2 to this pad." }
                  ]
              }
          ]
      }

    ]
}
