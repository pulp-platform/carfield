// Copyright 2018-2021 ETH Zurich and University of Bologna.
// Solderpad Hardware License, Version 0.51, see LICENSE for details.
// SPDX-License-Identifier: SHL-0.51
// Licensed under Solderpad Hardware License, Version 0.51, see LICENSE for details.
//
// Author: Davide Rossi  <davide.rossi@unibo.it>

{
  name: "cluster_control_unit"
  one_paragraph_desc: '''
  CL_CTRL_UNIT component manages the following features:
   - End of Computation status flag
   - Configurable fetch activation for all cores of the Cluster
   - Configurable core 0 boot address to define where to fetch first instruction in CL_CORE_0 after releasing the reset
   - Configurable full cluster clock gating
   - Configurable Cluster L1 memory arbitration policy
   - Cluster cores resume command control
   - Cluster cores halt status flags
   - Configurable cluster cores debug halt command group mask policy
  '''
  cip_id:  "36",
  version: "0.0.0" // null, commit c015839
  clocking: [
    {clock: "clk_i", reset: "rst_ni", primary: true}
  ],
  bus_interfaces: [
    { protocol: "tlul", direction: "device" }
  ],
  regwidth: "32"
  registers: [
    { name: "EOC"
      desc: "End Of Computation status register."
      swaccess: "rw"
      hwaccess: "hwo"
      fields: [
        { bits: "0:0"
          name: "eoc"
          resval: 0x0
          desc: '''End of computation status flag bitfield:
                - 1'b0: program execution under going
                - 1'b1: end of computation reached
		'''
        }
      ]
    }
    { name: "FETCH_EN"
      desc: "Cluster cores fetch enable configuration register."
      swaccess: "rw"
      hwaccess: "hro"
      fields: [
        { bits: "0"
          name: "CORE0"
          resval: 0x0
          desc: '''Core 0 fetch enable configuration bitfield:
                - 1'b0: disabled
                - 1'b1: enabled
                '''
        }
        { bits: "1"
          name: "CORE1"
          resval: 0x0
          desc: '''Core 1 fetch enable configuration bitfield:
                - 1'b0: disabled
                - 1'b1: enabled
                '''
        }
	{ bits: "2"
          name: "CORE2"
          resval: 0x0
          desc: '''Core 2 fetch enable configuration bitfield:
                - 1'b0: disabled
                - 1'b1: enabled
                '''
        }
	{ bits: "3"
          name: "CORE3"
          resval: 0x0
          desc: '''Core 3 fetch enable configuration bitfield:
                - 1'b0: disabled
                - 1'b1: enabled
                '''
        }
	{ bits: "4"
          name: "CORE4"
          resval: 0x0
          desc: '''Core 4 fetch enable configuration bitfield:
                - 1'b0: disabled
                - 1'b1: enabled
                '''
        }
	{ bits: "5"
          name: "CORE5"
          resval: 0x0
          desc: '''Core 5 fetch enable configuration bitfield:
                - 1'b0: disabled
                - 1'b1: enabled
                '''
        }
	{ bits: "6"
          name: "CORE6"
          resval: 0x0
          desc: '''Core 6 fetch enable configuration bitfield:
                - 1'b0: disabled
                - 1'b1: enabled
                '''
        }
	{ bits: "7"
          name: "CORE7"
          resval: 0x0
          desc: '''Core 7 fetch enable configuration bitfield:
                - 1'b0: disabled
                - 1'b1: enabled
                '''
        }
      ]
    }
    { name: "CLOCK_GATE"
      desc: "Cluster clock gate configuration register."
      swaccess: "rw"
      hwaccess: "hro"
      fields: [
        { bits: "0:0"
          name: "EN"
          resval: 0x0
          desc: '''Cluster clock gate configuration bitfield:
                - 1'b0: disabled
                - 1'b1: enabled
                '''
        }
      ]
    }
    { name: "DBG_RESUME"
      desc: "Cluster cores debug resume register."
      swaccess: "wo"
      hwaccess: "hro"
      fields: [
        { bits: "0"
          name: "CORE0"
          resval: 0x0
          desc: '''Core 0 debug resume configuration bitfield:
                - 1'b0: stay halted
                - 1'b1: resume core 0
                '''
        }
	{ bits: "1"
          name: "CORE1"
          resval: 0x0
          desc: '''Core 1 debug resume configuration bitfield:
                - 1'b0: stay halted
                - 1'b1: resume core 1
                '''
        }
	{ bits: "2"
          name: "CORE2"
          resval: 0x0
          desc: '''Core 2 debug resume configuration bitfield:
                - 1'b0: stay halted
                - 1'b1: resume core 2
                '''
        }
	{ bits: "3"
          name: "CORE3"
          resval: 0x0
          desc: '''Core 3 debug resume configuration bitfield:
                - 1'b0: stay halted
                - 1'b1: resume core 3
                '''
        }
	{ bits: "4"
          name: "CORE4"
          resval: 0x0
          desc: '''Core 4 debug resume configuration bitfield:
                - 1'b0: stay halted
                - 1'b1: resume core 4
                '''
        }
	{ bits: "5"
          name: "CORE5"
          resval: 0x0
          desc: '''Core 5 debug resume configuration bitfield:
                - 1'b0: stay halted
                - 1'b1: resume core 5
                '''
        }
	{ bits: "6"
          name: "CORE6"
          resval: 0x0
          desc: '''Core 6 debug resume configuration bitfield:
                - 1'b0: stay halted
                - 1'b1: resume core 6
                '''
        }
	{ bits: "7"
          name: "CORE7"
          resval: 0x0
          desc: '''Core 7 debug resume configuration bitfield:
                - 1'b0: stay halted
                - 1'b1: resume core 7
                '''
        }
      ]
    }
    { name: "DBG_HALT_STATUS"
      desc: "Cluster cores debug halt status register."
      swaccess: "ro"
      hwaccess: "hwo"
      fields: [
        { bits: "0"
          name: "CORE0"
          resval: 0x0
          desc: '''Core 0 debug halt status flag bitfield:
                - 1'b0: running
                - 1'b1: halted
                '''
        }
        { bits: "1"
          name: "CORE1"
          resval: 0x0
          desc: '''Core 1 debug halt status flag bitfield:
                - 1'b0: running
                - 1'b1: halted
                '''
        }
	{ bits: "2"
          name: "CORE2"
          resval: 0x0
          desc: '''Core 2 debug halt status flag bitfield:
		- 1'b0: running
                - 1'b1: halted
                '''
        }
	{ bits: "3"
          name: "CORE3"
          resval: 0x0
          desc: '''Core 3 debug halt status flag bitfield:
		- 1'b0: running
                - 1'b1: halted
                '''
        }
	{ bits: "4"
          name: "CORE4"
          resval: 0x0
          desc: '''Core 4 debug halt status flag bitfield:
		- 1'b0: running
                - 1'b1: halted
                '''
        }
	{ bits: "5"
          name: "CORE5"
          resval: 0x0
          desc: '''Core 5 debug halt status flag bitfield:
		- 1'b0: running
                - 1'b1: halted
                '''
        }
	{ bits: "6"
          name: "CORE6"
          resval: 0x0
          desc: '''Core 6 debug halt status flag bitfield:
		- 1'b0: running
                - 1'b1: halted
                '''
        }
	{ bits: "7"
          name: "CORE7"
          resval: 0x0
          desc: '''Core 7 debug halt status flag bitfield:
		- 1'b0: running
                - 1'b1: halted
                '''
        }
      ]
    }
    { name: "DBG_HALT_MASK"
      desc: "Cluster cores debug halt mask configuration register."
      swaccess: "rw"
      hwaccess: "hro"
      fields: [
        { bits: "0"
          name: "CORE0"
          resval: 0x0
          desc: '''Core 0 debug halt mask bitfield. When bit is set,
	        core will be part of mask group and stopped when one
		of the members of the group stops.
		'''
        }
	{ bits: "1"
          name: "CORE1"
          resval: 0x0
          desc:	'''Core 1 debug halt mask bitfield. When bit is set,
                core will be part of mask group and stopped when one
                of the members of the group stops.
                '''
        }
	{ bits: "2"
          name: "CORE2"
          resval: 0x0
          desc:	'''Core 2 debug halt mask bitfield. When bit is set,
                core will be part of mask group and stopped when one
                of the members of the group stops.
                '''
        }
	{ bits: "3"
          name: "CORE3"
          resval: 0x0
          desc:	'''Core 3 debug halt mask bitfield. When bit is set,
                core will be part of mask group and stopped when one
                of the members of the group stops.
                '''
        }
	{ bits: "4"
          name: "CORE4"
          resval: 0x0
          desc:	'''Core 4 debug halt mask bitfield. When bit is set,
                core will be part of mask group and stopped when one
                of the members of the group stops.
                '''
        }
	{ bits: "5"
          name: "CORE5"
          resval: 0x0
          desc:	'''Core 5 debug halt mask bitfield. When bit is set,
                core will be part of mask group and stopped when one
                of the members of the group stops.
                '''
        }
	{ bits: "6"
          name: "CORE6"
          resval: 0x0
          desc:	'''Core 6 debug halt mask bitfield. When bit is set,
                core will be part of mask group and stopped when one
                of the members of the group stops.
                '''
        }
	{ bits: "7"
          name: "CORE7"
          resval: 0x0
          desc:	'''Core 7 debug halt mask bitfield. When bit is set,
                core will be part of mask group and stopped when one
                of the members of the group stops.
                '''
        }
      ]
    }
    { name: "BOOT_ADDR0"
      desc: "Cluster core 0 boot address configuration register."
      swaccess: "rw"
      hwaccess: "hro"
      fields: [
        { bits: "31:0"
          name: "BA"
          resval: 0x0
          desc: "Cluster core 0 boot address configuration bitfield."
        }
      ]
    }
    { name: "TCDM_ARB_POLICY_CH0"
      desc: "TCDM arbitration policy ch0 for cluster cores configuration register."
      swaccess: "rw"
      hwaccess: "hro"
      fields: [
        { bits: "0:0"
          name: "POL"
          resval: 0x0
          desc: '''TCDM arbitration policy for cluster cores configuration bitfield:
                - 1'b0: fair round robin
                - 1'b1: fixed order
                '''
        }
      ]
    }
    { name: "TCDM_ARB_POLICY_CH1"
      desc: "TCDM arbitration policy ch1 for DMA/HWCE configuration register."
      swaccess: "rw"
      hwaccess: "hro"
      fields: [
        { bits: "0:0"
          name: "POL"
          resval: 0x0
          desc:	'''TCDM arbitration policy for DMA/HWCE configuration bitfield:
                - 1'b0: fair round robin
                - 1'b1: fixed order
      	      	'''
        }
      ]
    }
    { name: "TCDM_ARB_POLICY_CH0_REP"
      desc: "Read only duplicate of TCDM_ARB_POLICY_CH0 register"
      swaccess: "rw"
      hwaccess: "hro"
      fields: [
        { bits: "0:0"
          name: "POL"
          resval: 0x0
          desc: '''TCDM arbitration policy for cluster cores configuration bitfield:
                - 1'b0: fair round robin
                - 1'b1: fixed order
                '''
        }
      ]
    }
    { name: "TCDM_ARB_POLICY_CH1_REP"
      desc: "Read only duplicate of TCDM_ARB_POLICY_CH1 register"
      swaccess: "rw"
      hwaccess: "hro"
      fields: [
        { bits: "0:0"
          name: "POL"
          resval: 0x0
          desc: '''TCDM arbitration policy for DMA/HWCE configuration bitfield:
                - 1'b0: fair round robin
                - 1'b1: fixed order
                '''
        }
      ]
    }
  ]
}
