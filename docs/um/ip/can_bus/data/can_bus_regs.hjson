// Copyright 2015-2024 Czech Technical University in Prague
// Licensed under a dual MIT / Non-commercial license; see LICENSE for details.
// SPDX-License-Identifier: MIT AND LicenseRef-CTU-NC
//
// Developed by:
//   Ondrej Ille <ondrej.ille@gmail.com>
//   Martin Jerabek <martin.jerabek01@gmail.com>
//
// CTU CAN FD IP Core – Department of Measurement, CTU in Prague
// Register layout of CAN BUS

{
  name: "can_bus",
  human_name: "CAN Bus Controller",
  one_line_desc: "Controller for CAN Bus communication",
  one_paragraph_desc: '''The CAN Bus Controller IP facilitates communication over the Controller Area Network (CAN) protocol.
                      It supports both standard and extended frames, with configurable baud rates, interrupt handling, and filtering capabilities.
                      ''',
  cip_id: "36",
  version: "0.0.0", //null, 0ec0bf8
  regwidth: "32",
  clocking: [
    { clock: "clk_i", reset: "rst_ni", idle: "idle_o", primary: true }
  ],
  bus_interfaces: [
    { protocol: "tlul", direction: "device" }
  ],
  registers: [
    {
      name: "ahb_ifc_hsel_valid",
      desc: "Auto-extracted signal hsel_valid from ahb_ifc.vhd",
      swaccess: "rw",
      hwaccess: "hrw",
      fields: [
        {
          name: "value",
          bits: "31:0",
          desc: "Placeholder 32-bit field for extracted signal"
        }
      ]
    },
    {
      name: "ahb_ifc_write_acc_d",
      desc: "Auto-extracted signal write_acc_d from ahb_ifc.vhd",
      swaccess: "rw",
      hwaccess: "hrw",
      fields: [
        {
          name: "value",
          bits: "31:0",
          desc: "Placeholder 32-bit field for extracted signal"
        }
      ]
    },
    {
      name: "ahb_ifc_write_acc_q",
      desc: "Auto-extracted signal write_acc_q from ahb_ifc.vhd",
      swaccess: "rw",
      hwaccess: "hrw",
      fields: [
        {
          name: "value",
          bits: "31:0",
          desc: "Placeholder 32-bit field for extracted signal"
        }
      ]
    },
    {
      name: "ahb_ifc_haddr_q",
      desc: "Auto-extracted signal haddr_q from ahb_ifc.vhd",
      swaccess: "rw",
      hwaccess: "hrw",
      fields: [
        {
          name: "value",
          bits: "31:0",
          desc: "Placeholder 32-bit field for extracted signal"
        }
      ]
    },
    {
      name: "ahb_ifc_h_ready_raw",
      desc: "Auto-extracted signal h_ready_raw from ahb_ifc.vhd",
      swaccess: "rw",
      hwaccess: "hrw",
      fields: [
        {
          name: "value",
          bits: "31:0",
          desc: "Placeholder 32-bit field for extracted signal"
        }
      ]
    },
    {
      name: "ahb_ifc_sbe_d",
      desc: "Auto-extracted signal sbe_d from ahb_ifc.vhd",
      swaccess: "rw",
      hwaccess: "hrw",
      fields: [
        {
          name: "value",
          bits: "31:0",
          desc: "Placeholder 32-bit field for extracted signal"
        }
      ]
    },
    {
      name: "ahb_ifc_sbe_q",
      desc: "Auto-extracted signal sbe_q from ahb_ifc.vhd",
      swaccess: "rw",
      hwaccess: "hrw",
      fields: [
        {
          name: "value",
          bits: "31:0",
          desc: "Placeholder 32-bit field for extracted signal"
        }
      ]
    },
    {
      name: "ahb_ifc_swr_i",
      desc: "Auto-extracted signal swr_i from ahb_ifc.vhd",
      swaccess: "rw",
      hwaccess: "hrw",
      fields: [
        {
          name: "value",
          bits: "31:0",
          desc: "Placeholder 32-bit field for extracted signal"
        }
      ]
    },
    {
      name: "ahb_ifc_srd_i",
      desc: "Auto-extracted signal srd_i from ahb_ifc.vhd",
      swaccess: "rw",
      hwaccess: "hrw",
      fields: [
        {
          name: "value",
          bits: "31:0",
          desc: "Placeholder 32-bit field for extracted signal"
        }
      ]
    },
    {
      name: "bit_destuffing_discard_stuff_bit",
      desc: "Auto-extracted signal discard_stuff_bit from bit_destuffing.vhd",
      swaccess: "rw",
      hwaccess: "hrw",
      fields: [
        {
          name: "value",
          bits: "31:0",
          desc: "Placeholder 32-bit field for extracted signal"
        }
      ]
    },
    {
      name: "bit_destuffing_non_fix_to_fix_chng",
      desc: "Auto-extracted signal non_fix_to_fix_chng from bit_destuffing.vhd",
      swaccess: "rw",
      hwaccess: "hrw",
      fields: [
        {
          name: "value",
          bits: "31:0",
          desc: "Placeholder 32-bit field for extracted signal"
        }
      ]
    },
    {
      name: "bit_destuffing_stuff_lvl_reached",
      desc: "Auto-extracted signal stuff_lvl_reached from bit_destuffing.vhd",
      swaccess: "rw",
      hwaccess: "hrw",
      fields: [
        {
          name: "value",
          bits: "31:0",
          desc: "Placeholder 32-bit field for extracted signal"
        }
      ]
    },
    {
      name: "bit_destuffing_stuff_rule_violate",
      desc: "Auto-extracted signal stuff_rule_violate from bit_destuffing.vhd",
      swaccess: "rw",
      hwaccess: "hrw",
      fields: [
        {
          name: "value",
          bits: "31:0",
          desc: "Placeholder 32-bit field for extracted signal"
        }
      ]
    },
    {
      name: "bit_destuffing_enable_prev",
      desc: "Auto-extracted signal enable_prev from bit_destuffing.vhd",
      swaccess: "rw",
      hwaccess: "hrw",
      fields: [
        {
          name: "value",
          bits: "31:0",
          desc: "Placeholder 32-bit field for extracted signal"
        }
      ]
    },
    {
      name: "bit_destuffing_fixed_prev_q",
      desc: "Auto-extracted signal fixed_prev_q from bit_destuffing.vhd",
      swaccess: "rw",
      hwaccess: "hrw",
      fields: [
        {
          name: "value",
          bits: "31:0",
          desc: "Placeholder 32-bit field for extracted signal"
        }
      ]
    },
    {
      name: "bit_destuffing_fixed_prev_d",
      desc: "Auto-extracted signal fixed_prev_d from bit_destuffing.vhd",
      swaccess: "rw",
      hwaccess: "hrw",
      fields: [
        {
          name: "value",
          bits: "31:0",
          desc: "Placeholder 32-bit field for extracted signal"
        }
      ]
    },
    {
      name: "bit_destuffing_same_bits_erase",
      desc: "Auto-extracted signal same_bits_erase from bit_destuffing.vhd",
      swaccess: "rw",
      hwaccess: "hrw",
      fields: [
        {
          name: "value",
          bits: "31:0",
          desc: "Placeholder 32-bit field for extracted signal"
        }
      ]
    },
    {
      name: "bit_destuffing_destuffed_q",
      desc: "Auto-extracted signal destuffed_q from bit_destuffing.vhd",
      swaccess: "rw",
      hwaccess: "hrw",
      fields: [
        {
          name: "value",
          bits: "31:0",
          desc: "Placeholder 32-bit field for extracted signal"
        }
      ]
    },
    {
      name: "bit_destuffing_destuffed_d",
      desc: "Auto-extracted signal destuffed_d from bit_destuffing.vhd",
      swaccess: "rw",
      hwaccess: "hrw",
      fields: [
        {
          name: "value",
          bits: "31:0",
          desc: "Placeholder 32-bit field for extracted signal"
        }
      ]
    },
    {
      name: "bit_destuffing_stuff_err_q",
      desc: "Auto-extracted signal stuff_err_q from bit_destuffing.vhd",
      swaccess: "rw",
      hwaccess: "hrw",
      fields: [
        {
          name: "value",
          bits: "31:0",
          desc: "Placeholder 32-bit field for extracted signal"
        }
      ]
    },
    {
      name: "bit_destuffing_stuff_err_d",
      desc: "Auto-extracted signal stuff_err_d from bit_destuffing.vhd",
      swaccess: "rw",
      hwaccess: "hrw",
      fields: [
        {
          name: "value",
          bits: "31:0",
          desc: "Placeholder 32-bit field for extracted signal"
        }
      ]
    },
    {
      name: "bit_destuffing_prev_val_q",
      desc: "Auto-extracted signal prev_val_q from bit_destuffing.vhd",
      swaccess: "rw",
      hwaccess: "hrw",
      fields: [
        {
          name: "value",
          bits: "31:0",
          desc: "Placeholder 32-bit field for extracted signal"
        }
      ]
    },
    {
      name: "bit_destuffing_prev_val_d",
      desc: "Auto-extracted signal prev_val_d from bit_destuffing.vhd",
      swaccess: "rw",
      hwaccess: "hrw",
      fields: [
        {
          name: "value",
          bits: "31:0",
          desc: "Placeholder 32-bit field for extracted signal"
        }
      ]
    },
    {
      name: "bit_err_detector_bit_err_d",
      desc: "Auto-extracted signal bit_err_d from bit_err_detector.vhd",
      swaccess: "rw",
      hwaccess: "hrw",
      fields: [
        {
          name: "value",
          bits: "31:0",
          desc: "Placeholder 32-bit field for extracted signal"
        }
      ]
    },
    {
      name: "bit_err_detector_bit_err_q",
      desc: "Auto-extracted signal bit_err_q from bit_err_detector.vhd",
      swaccess: "rw",
      hwaccess: "hrw",
      fields: [
        {
          name: "value",
          bits: "31:0",
          desc: "Placeholder 32-bit field for extracted signal"
        }
      ]
    },
    {
      name: "bit_err_detector_bit_err_ssp_capt_d",
      desc: "Auto-extracted signal bit_err_ssp_capt_d from bit_err_detector.vhd",
      swaccess: "rw",
      hwaccess: "hrw",
      fields: [
        {
          name: "value",
          bits: "31:0",
          desc: "Placeholder 32-bit field for extracted signal"
        }
      ]
    },
    {
      name: "bit_err_detector_bit_err_ssp_capt_q",
      desc: "Auto-extracted signal bit_err_ssp_capt_q from bit_err_detector.vhd",
      swaccess: "rw",
      hwaccess: "hrw",
      fields: [
        {
          name: "value",
          bits: "31:0",
          desc: "Placeholder 32-bit field for extracted signal"
        }
      ]
    },
    {
      name: "bit_err_detector_bit_err_ssp_valid",
      desc: "Auto-extracted signal bit_err_ssp_valid from bit_err_detector.vhd",
      swaccess: "rw",
      hwaccess: "hrw",
      fields: [
        {
          name: "value",
          bits: "31:0",
          desc: "Placeholder 32-bit field for extracted signal"
        }
      ]
    },
    {
      name: "bit_err_detector_bit_err_ssp_condition",
      desc: "Auto-extracted signal bit_err_ssp_condition from bit_err_detector.vhd",
      swaccess: "rw",
      hwaccess: "hrw",
      fields: [
        {
          name: "value",
          bits: "31:0",
          desc: "Placeholder 32-bit field for extracted signal"
        }
      ]
    },
    {
      name: "bit_err_detector_bit_err_norm_valid",
      desc: "Auto-extracted signal bit_err_norm_valid from bit_err_detector.vhd",
      swaccess: "rw",
      hwaccess: "hrw",
      fields: [
        {
          name: "value",
          bits: "31:0",
          desc: "Placeholder 32-bit field for extracted signal"
        }
      ]
    },
    {
      name: "bit_filter_masked_input",
      desc: "Auto-extracted signal masked_input from bit_filter.vhd",
      swaccess: "rw",
      hwaccess: "hrw",
      fields: [
        {
          name: "value",
          bits: "31:0",
          desc: "Placeholder 32-bit field for extracted signal"
        }
      ]
    },
    {
      name: "bit_filter_masked_value",
      desc: "Auto-extracted signal masked_value from bit_filter.vhd",
      swaccess: "rw",
      hwaccess: "hrw",
      fields: [
        {
          name: "value",
          bits: "31:0",
          desc: "Placeholder 32-bit field for extracted signal"
        }
      ]
    },
    {
      name: "bit_segment_meter_sel_tseg1",
      desc: "Auto-extracted signal sel_tseg1 from bit_segment_meter.vhd",
      swaccess: "rw",
      hwaccess: "hrw",
      fields: [
        {
          name: "value",
          bits: "31:0",
          desc: "Placeholder 32-bit field for extracted signal"
        }
      ]
    },
    {
      name: "bit_segment_meter_exp_seg_length_ce",
      desc: "Auto-extracted signal exp_seg_length_ce from bit_segment_meter.vhd",
      swaccess: "rw",
      hwaccess: "hrw",
      fields: [
        {
          name: "value",
          bits: "31:0",
          desc: "Placeholder 32-bit field for extracted signal"
        }
      ]
    },
    {
      name: "bit_segment_meter_phase_err_mt_sjw",
      desc: "Auto-extracted signal phase_err_mt_sjw from bit_segment_meter.vhd",
      swaccess: "rw",
      hwaccess: "hrw",
      fields: [
        {
          name: "value",
          bits: "31:0",
          desc: "Placeholder 32-bit field for extracted signal"
        }
      ]
    },
    {
      name: "bit_segment_meter_phase_err_eq_sjw",
      desc: "Auto-extracted signal phase_err_eq_sjw from bit_segment_meter.vhd",
      swaccess: "rw",
      hwaccess: "hrw",
      fields: [
        {
          name: "value",
          bits: "31:0",
          desc: "Placeholder 32-bit field for extracted signal"
        }
      ]
    },
    {
      name: "bit_segment_meter_exit_ph2_immediate",
      desc: "Auto-extracted signal exit_ph2_immediate from bit_segment_meter.vhd",
      swaccess: "rw",
      hwaccess: "hrw",
      fields: [
        {
          name: "value",
          bits: "31:0",
          desc: "Placeholder 32-bit field for extracted signal"
        }
      ]
    },
    {
      name: "bit_segment_meter_exit_segm_regular",
      desc: "Auto-extracted signal exit_segm_regular from bit_segment_meter.vhd",
      swaccess: "rw",
      hwaccess: "hrw",
      fields: [
        {
          name: "value",
          bits: "31:0",
          desc: "Placeholder 32-bit field for extracted signal"
        }
      ]
    },
    {
      name: "bit_segment_meter_exit_segm_regular_tseg1",
      desc: "Auto-extracted signal exit_segm_regular_tseg1 from bit_segment_meter.vhd",
      swaccess: "rw",
      hwaccess: "hrw",
      fields: [
        {
          name: "value",
          bits: "31:0",
          desc: "Placeholder 32-bit field for extracted signal"
        }
      ]
    },
    {
      name: "bit_segment_meter_exit_segm_regular_tseg2",
      desc: "Auto-extracted signal exit_segm_regular_tseg2 from bit_segment_meter.vhd",
      swaccess: "rw",
      hwaccess: "hrw",
      fields: [
        {
          name: "value",
          bits: "31:0",
          desc: "Placeholder 32-bit field for extracted signal"
        }
      ]
    },
    {
      name: "bit_segment_meter_sjw_mt_zero",
      desc: "Auto-extracted signal sjw_mt_zero from bit_segment_meter.vhd",
      swaccess: "rw",
      hwaccess: "hrw",
      fields: [
        {
          name: "value",
          bits: "31:0",
          desc: "Placeholder 32-bit field for extracted signal"
        }
      ]
    },
    {
      name: "bit_segment_meter_use_basic_segm_length",
      desc: "Auto-extracted signal use_basic_segm_length from bit_segment_meter.vhd",
      swaccess: "rw",
      hwaccess: "hrw",
      fields: [
        {
          name: "value",
          bits: "31:0",
          desc: "Placeholder 32-bit field for extracted signal"
        }
      ]
    },
    {
      name: "bit_segment_meter_phase_err_sjw_by_one",
      desc: "Auto-extracted signal phase_err_sjw_by_one from bit_segment_meter.vhd",
      swaccess: "rw",
      hwaccess: "hrw",
      fields: [
        {
          name: "value",
          bits: "31:0",
          desc: "Placeholder 32-bit field for extracted signal"
        }
      ]
    },
    {
      name: "bit_segment_meter_shorten_tseg1_after_tseg2",
      desc: "Auto-extracted signal shorten_tseg1_after_tseg2 from bit_segment_meter.vhd",
      swaccess: "rw",
      hwaccess: "hrw",
      fields: [
        {
          name: "value",
          bits: "31:0",
          desc: "Placeholder 32-bit field for extracted signal"
        }
      ]
    },
    {
      name: "bit_stuffing_data_out_i",
      desc: "Auto-extracted signal data_out_i from bit_stuffing.vhd",
      swaccess: "rw",
      hwaccess: "hrw",
      fields: [
        {
          name: "value",
          bits: "31:0",
          desc: "Placeholder 32-bit field for extracted signal"
        }
      ]
    },
    {
      name: "bit_stuffing_data_halt_q",
      desc: "Auto-extracted signal data_halt_q from bit_stuffing.vhd",
      swaccess: "rw",
      hwaccess: "hrw",
      fields: [
        {
          name: "value",
          bits: "31:0",
          desc: "Placeholder 32-bit field for extracted signal"
        }
      ]
    },
    {
      name: "bit_stuffing_data_halt_d",
      desc: "Auto-extracted signal data_halt_d from bit_stuffing.vhd",
      swaccess: "rw",
      hwaccess: "hrw",
      fields: [
        {
          name: "value",
          bits: "31:0",
          desc: "Placeholder 32-bit field for extracted signal"
        }
      ]
    },
    {
      name: "bit_stuffing_fixed_reg_q",
      desc: "Auto-extracted signal fixed_reg_q from bit_stuffing.vhd",
      swaccess: "rw",
      hwaccess: "hrw",
      fields: [
        {
          name: "value",
          bits: "31:0",
          desc: "Placeholder 32-bit field for extracted signal"
        }
      ]
    },
    {
      name: "bit_stuffing_fixed_reg_d",
      desc: "Auto-extracted signal fixed_reg_d from bit_stuffing.vhd",
      swaccess: "rw",
      hwaccess: "hrw",
      fields: [
        {
          name: "value",
          bits: "31:0",
          desc: "Placeholder 32-bit field for extracted signal"
        }
      ]
    },
    {
      name: "bit_stuffing_enable_prev",
      desc: "Auto-extracted signal enable_prev from bit_stuffing.vhd",
      swaccess: "rw",
      hwaccess: "hrw",
      fields: [
        {
          name: "value",
          bits: "31:0",
          desc: "Placeholder 32-bit field for extracted signal"
        }
      ]
    },
    {
      name: "bit_stuffing_non_fix_to_fix_chng",
      desc: "Auto-extracted signal non_fix_to_fix_chng from bit_stuffing.vhd",
      swaccess: "rw",
      hwaccess: "hrw",
      fields: [
        {
          name: "value",
          bits: "31:0",
          desc: "Placeholder 32-bit field for extracted signal"
        }
      ]
    },
    {
      name: "bit_stuffing_stuff_lvl_reached",
      desc: "Auto-extracted signal stuff_lvl_reached from bit_stuffing.vhd",
      swaccess: "rw",
      hwaccess: "hrw",
      fields: [
        {
          name: "value",
          bits: "31:0",
          desc: "Placeholder 32-bit field for extracted signal"
        }
      ]
    },
    {
      name: "bit_stuffing_same_bits_rst_trig",
      desc: "Auto-extracted signal same_bits_rst_trig from bit_stuffing.vhd",
      swaccess: "rw",
      hwaccess: "hrw",
      fields: [
        {
          name: "value",
          bits: "31:0",
          desc: "Placeholder 32-bit field for extracted signal"
        }
      ]
    },
    {
      name: "bit_stuffing_same_bits_rst",
      desc: "Auto-extracted signal same_bits_rst from bit_stuffing.vhd",
      swaccess: "rw",
      hwaccess: "hrw",
      fields: [
        {
          name: "value",
          bits: "31:0",
          desc: "Placeholder 32-bit field for extracted signal"
        }
      ]
    },
    {
      name: "bit_stuffing_insert_stuff_bit",
      desc: "Auto-extracted signal insert_stuff_bit from bit_stuffing.vhd",
      swaccess: "rw",
      hwaccess: "hrw",
      fields: [
        {
          name: "value",
          bits: "31:0",
          desc: "Placeholder 32-bit field for extracted signal"
        }
      ]
    },
    {
      name: "bit_stuffing_data_out_d_ena",
      desc: "Auto-extracted signal data_out_d_ena from bit_stuffing.vhd",
      swaccess: "rw",
      hwaccess: "hrw",
      fields: [
        {
          name: "value",
          bits: "31:0",
          desc: "Placeholder 32-bit field for extracted signal"
        }
      ]
    },
    {
      name: "bit_stuffing_data_out_d",
      desc: "Auto-extracted signal data_out_d from bit_stuffing.vhd",
      swaccess: "rw",
      hwaccess: "hrw",
      fields: [
        {
          name: "value",
          bits: "31:0",
          desc: "Placeholder 32-bit field for extracted signal"
        }
      ]
    },
    {
      name: "bit_stuffing_data_out_ce",
      desc: "Auto-extracted signal data_out_ce from bit_stuffing.vhd",
      swaccess: "rw",
      hwaccess: "hrw",
      fields: [
        {
          name: "value",
          bits: "31:0",
          desc: "Placeholder 32-bit field for extracted signal"
        }
      ]
    },
    {
      name: "bit_time_cfg_capture_drv_tq_nbt",
      desc: "Auto-extracted signal drv_tq_nbt from bit_time_cfg_capture.vhd",
      swaccess: "rw",
      hwaccess: "hrw",
      fields: [
        {
          name: "value",
          bits: "31:0",
          desc: "Placeholder 32-bit field for extracted signal"
        }
      ]
    },
    {
      name: "bit_time_cfg_capture_drv_prs_nbt",
      desc: "Auto-extracted signal drv_prs_nbt from bit_time_cfg_capture.vhd",
      swaccess: "rw",
      hwaccess: "hrw",
      fields: [
        {
          name: "value",
          bits: "31:0",
          desc: "Placeholder 32-bit field for extracted signal"
        }
      ]
    },
    {
      name: "bit_time_cfg_capture_drv_ph1_nbt",
      desc: "Auto-extracted signal drv_ph1_nbt from bit_time_cfg_capture.vhd",
      swaccess: "rw",
      hwaccess: "hrw",
      fields: [
        {
          name: "value",
          bits: "31:0",
          desc: "Placeholder 32-bit field for extracted signal"
        }
      ]
    },
    {
      name: "bit_time_cfg_capture_drv_ph2_nbt",
      desc: "Auto-extracted signal drv_ph2_nbt from bit_time_cfg_capture.vhd",
      swaccess: "rw",
      hwaccess: "hrw",
      fields: [
        {
          name: "value",
          bits: "31:0",
          desc: "Placeholder 32-bit field for extracted signal"
        }
      ]
    },
    {
      name: "bit_time_cfg_capture_drv_sjw_nbt",
      desc: "Auto-extracted signal drv_sjw_nbt from bit_time_cfg_capture.vhd",
      swaccess: "rw",
      hwaccess: "hrw",
      fields: [
        {
          name: "value",
          bits: "31:0",
          desc: "Placeholder 32-bit field for extracted signal"
        }
      ]
    },
    {
      name: "bit_time_cfg_capture_drv_tq_dbt",
      desc: "Auto-extracted signal drv_tq_dbt from bit_time_cfg_capture.vhd",
      swaccess: "rw",
      hwaccess: "hrw",
      fields: [
        {
          name: "value",
          bits: "31:0",
          desc: "Placeholder 32-bit field for extracted signal"
        }
      ]
    },
    {
      name: "bit_time_cfg_capture_drv_prs_dbt",
      desc: "Auto-extracted signal drv_prs_dbt from bit_time_cfg_capture.vhd",
      swaccess: "rw",
      hwaccess: "hrw",
      fields: [
        {
          name: "value",
          bits: "31:0",
          desc: "Placeholder 32-bit field for extracted signal"
        }
      ]
    },
    {
      name: "bit_time_cfg_capture_drv_ph1_dbt",
      desc: "Auto-extracted signal drv_ph1_dbt from bit_time_cfg_capture.vhd",
      swaccess: "rw",
      hwaccess: "hrw",
      fields: [
        {
          name: "value",
          bits: "31:0",
          desc: "Placeholder 32-bit field for extracted signal"
        }
      ]
    },
    {
      name: "bit_time_cfg_capture_drv_ph2_dbt",
      desc: "Auto-extracted signal drv_ph2_dbt from bit_time_cfg_capture.vhd",
      swaccess: "rw",
      hwaccess: "hrw",
      fields: [
        {
          name: "value",
          bits: "31:0",
          desc: "Placeholder 32-bit field for extracted signal"
        }
      ]
    },
    {
      name: "bit_time_cfg_capture_drv_sjw_dbt",
      desc: "Auto-extracted signal drv_sjw_dbt from bit_time_cfg_capture.vhd",
      swaccess: "rw",
      hwaccess: "hrw",
      fields: [
        {
          name: "value",
          bits: "31:0",
          desc: "Placeholder 32-bit field for extracted signal"
        }
      ]
    },
    {
      name: "bit_time_cfg_capture_tseg1_nbt_d",
      desc: "Auto-extracted signal tseg1_nbt_d from bit_time_cfg_capture.vhd",
      swaccess: "rw",
      hwaccess: "hrw",
      fields: [
        {
          name: "value",
          bits: "31:0",
          desc: "Placeholder 32-bit field for extracted signal"
        }
      ]
    },
    {
      name: "bit_time_cfg_capture_tseg1_dbt_d",
      desc: "Auto-extracted signal tseg1_dbt_d from bit_time_cfg_capture.vhd",
      swaccess: "rw",
      hwaccess: "hrw",
      fields: [
        {
          name: "value",
          bits: "31:0",
          desc: "Placeholder 32-bit field for extracted signal"
        }
      ]
    },
    {
      name: "bit_time_cfg_capture_drv_ena",
      desc: "Auto-extracted signal drv_ena from bit_time_cfg_capture.vhd",
      swaccess: "rw",
      hwaccess: "hrw",
      fields: [
        {
          name: "value",
          bits: "31:0",
          desc: "Placeholder 32-bit field for extracted signal"
        }
      ]
    },
    {
      name: "bit_time_cfg_capture_drv_ena_reg",
      desc: "Auto-extracted signal drv_ena_reg from bit_time_cfg_capture.vhd",
      swaccess: "rw",
      hwaccess: "hrw",
      fields: [
        {
          name: "value",
          bits: "31:0",
          desc: "Placeholder 32-bit field for extracted signal"
        }
      ]
    },
    {
      name: "bit_time_cfg_capture_drv_ena_reg_2",
      desc: "Auto-extracted signal drv_ena_reg_2 from bit_time_cfg_capture.vhd",
      swaccess: "rw",
      hwaccess: "hrw",
      fields: [
        {
          name: "value",
          bits: "31:0",
          desc: "Placeholder 32-bit field for extracted signal"
        }
      ]
    },
    {
      name: "bit_time_cfg_capture_capture",
      desc: "Auto-extracted signal capture from bit_time_cfg_capture.vhd",
      swaccess: "rw",
      hwaccess: "hrw",
      fields: [
        {
          name: "value",
          bits: "31:0",
          desc: "Placeholder 32-bit field for extracted signal"
        }
      ]
    },
    {
      name: "bit_time_counters_tq_counter_d",
      desc: "Auto-extracted signal tq_counter_d from bit_time_counters.vhd",
      swaccess: "rw",
      hwaccess: "hrw",
      fields: [
        {
          name: "value",
          bits: "31:0",
          desc: "Placeholder 32-bit field for extracted signal"
        }
      ]
    },
    {
      name: "bit_time_counters_tq_counter_q",
      desc: "Auto-extracted signal tq_counter_q from bit_time_counters.vhd",
      swaccess: "rw",
      hwaccess: "hrw",
      fields: [
        {
          name: "value",
          bits: "31:0",
          desc: "Placeholder 32-bit field for extracted signal"
        }
      ]
    },
    {
      name: "bit_time_counters_tq_counter_ce",
      desc: "Auto-extracted signal tq_counter_ce from bit_time_counters.vhd",
      swaccess: "rw",
      hwaccess: "hrw",
      fields: [
        {
          name: "value",
          bits: "31:0",
          desc: "Placeholder 32-bit field for extracted signal"
        }
      ]
    },
    {
      name: "bit_time_counters_tq_counter_allow",
      desc: "Auto-extracted signal tq_counter_allow from bit_time_counters.vhd",
      swaccess: "rw",
      hwaccess: "hrw",
      fields: [
        {
          name: "value",
          bits: "31:0",
          desc: "Placeholder 32-bit field for extracted signal"
        }
      ]
    },
    {
      name: "bit_time_counters_tq_edge_i",
      desc: "Auto-extracted signal tq_edge_i from bit_time_counters.vhd",
      swaccess: "rw",
      hwaccess: "hrw",
      fields: [
        {
          name: "value",
          bits: "31:0",
          desc: "Placeholder 32-bit field for extracted signal"
        }
      ]
    },
    {
      name: "bit_time_counters_segm_counter_d",
      desc: "Auto-extracted signal segm_counter_d from bit_time_counters.vhd",
      swaccess: "rw",
      hwaccess: "hrw",
      fields: [
        {
          name: "value",
          bits: "31:0",
          desc: "Placeholder 32-bit field for extracted signal"
        }
      ]
    },
    {
      name: "bit_time_counters_segm_counter_q",
      desc: "Auto-extracted signal segm_counter_q from bit_time_counters.vhd",
      swaccess: "rw",
      hwaccess: "hrw",
      fields: [
        {
          name: "value",
          bits: "31:0",
          desc: "Placeholder 32-bit field for extracted signal"
        }
      ]
    },
    {
      name: "bit_time_counters_segm_counter_ce",
      desc: "Auto-extracted signal segm_counter_ce from bit_time_counters.vhd",
      swaccess: "rw",
      hwaccess: "hrw",
      fields: [
        {
          name: "value",
          bits: "31:0",
          desc: "Placeholder 32-bit field for extracted signal"
        }
      ]
    },
    {
      name: "bit_time_fsm_bt_fsm_ce",
      desc: "Auto-extracted signal bt_fsm_ce from bit_time_fsm.vhd",
      swaccess: "rw",
      hwaccess: "hrw",
      fields: [
        {
          name: "value",
          bits: "31:0",
          desc: "Placeholder 32-bit field for extracted signal"
        }
      ]
    },
    {
      name: "bus_sampling_drv_ena",
      desc: "Auto-extracted signal drv_ena from bus_sampling.vhd",
      swaccess: "rw",
      hwaccess: "hrw",
      fields: [
        {
          name: "value",
          bits: "31:0",
          desc: "Placeholder 32-bit field for extracted signal"
        }
      ]
    },
    {
      name: "bus_sampling_drv_ssp_offset",
      desc: "Auto-extracted signal drv_ssp_offset from bus_sampling.vhd",
      swaccess: "rw",
      hwaccess: "hrw",
      fields: [
        {
          name: "value",
          bits: "31:0",
          desc: "Placeholder 32-bit field for extracted signal"
        }
      ]
    },
    {
      name: "bus_sampling_drv_ssp_delay_select",
      desc: "Auto-extracted signal drv_ssp_delay_select from bus_sampling.vhd",
      swaccess: "rw",
      hwaccess: "hrw",
      fields: [
        {
          name: "value",
          bits: "31:0",
          desc: "Placeholder 32-bit field for extracted signal"
        }
      ]
    },
    {
      name: "bus_sampling_data_rx_synced",
      desc: "Auto-extracted signal data_rx_synced from bus_sampling.vhd",
      swaccess: "rw",
      hwaccess: "hrw",
      fields: [
        {
          name: "value",
          bits: "31:0",
          desc: "Placeholder 32-bit field for extracted signal"
        }
      ]
    },
    {
      name: "bus_sampling_prev_Sample",
      desc: "Auto-extracted signal prev_Sample from bus_sampling.vhd",
      swaccess: "rw",
      hwaccess: "hrw",
      fields: [
        {
          name: "value",
          bits: "31:0",
          desc: "Placeholder 32-bit field for extracted signal"
        }
      ]
    },
    {
      name: "bus_sampling_sample_sec_i",
      desc: "Auto-extracted signal sample_sec_i from bus_sampling.vhd",
      swaccess: "rw",
      hwaccess: "hrw",
      fields: [
        {
          name: "value",
          bits: "31:0",
          desc: "Placeholder 32-bit field for extracted signal"
        }
      ]
    },
    {
      name: "bus_sampling_data_tx_delayed",
      desc: "Auto-extracted signal data_tx_delayed from bus_sampling.vhd",
      swaccess: "rw",
      hwaccess: "hrw",
      fields: [
        {
          name: "value",
          bits: "31:0",
          desc: "Placeholder 32-bit field for extracted signal"
        }
      ]
    },
    {
      name: "bus_sampling_edge_rx_valid",
      desc: "Auto-extracted signal edge_rx_valid from bus_sampling.vhd",
      swaccess: "rw",
      hwaccess: "hrw",
      fields: [
        {
          name: "value",
          bits: "31:0",
          desc: "Placeholder 32-bit field for extracted signal"
        }
      ]
    },
    {
      name: "bus_sampling_edge_tx_valid",
      desc: "Auto-extracted signal edge_tx_valid from bus_sampling.vhd",
      swaccess: "rw",
      hwaccess: "hrw",
      fields: [
        {
          name: "value",
          bits: "31:0",
          desc: "Placeholder 32-bit field for extracted signal"
        }
      ]
    },
    {
      name: "bus_sampling_ssp_delay",
      desc: "Auto-extracted signal ssp_delay from bus_sampling.vhd",
      swaccess: "rw",
      hwaccess: "hrw",
      fields: [
        {
          name: "value",
          bits: "31:0",
          desc: "Placeholder 32-bit field for extracted signal"
        }
      ]
    },
    {
      name: "bus_sampling_tx_trigger_q",
      desc: "Auto-extracted signal tx_trigger_q from bus_sampling.vhd",
      swaccess: "rw",
      hwaccess: "hrw",
      fields: [
        {
          name: "value",
          bits: "31:0",
          desc: "Placeholder 32-bit field for extracted signal"
        }
      ]
    },
    {
      name: "bus_sampling_tx_trigger_ssp",
      desc: "Auto-extracted signal tx_trigger_ssp from bus_sampling.vhd",
      swaccess: "rw",
      hwaccess: "hrw",
      fields: [
        {
          name: "value",
          bits: "31:0",
          desc: "Placeholder 32-bit field for extracted signal"
        }
      ]
    },
    {
      name: "bus_sampling_shift_regs_res_d",
      desc: "Auto-extracted signal shift_regs_res_d from bus_sampling.vhd",
      swaccess: "rw",
      hwaccess: "hrw",
      fields: [
        {
          name: "value",
          bits: "31:0",
          desc: "Placeholder 32-bit field for extracted signal"
        }
      ]
    },
    {
      name: "bus_sampling_shift_regs_res_q",
      desc: "Auto-extracted signal shift_regs_res_q from bus_sampling.vhd",
      swaccess: "rw",
      hwaccess: "hrw",
      fields: [
        {
          name: "value",
          bits: "31:0",
          desc: "Placeholder 32-bit field for extracted signal"
        }
      ]
    },
    {
      name: "bus_sampling_shift_regs_res_q_scan",
      desc: "Auto-extracted signal shift_regs_res_q_scan from bus_sampling.vhd",
      swaccess: "rw",
      hwaccess: "hrw",
      fields: [
        {
          name: "value",
          bits: "31:0",
          desc: "Placeholder 32-bit field for extracted signal"
        }
      ]
    },
    {
      name: "bus_sampling_ssp_enable",
      desc: "Auto-extracted signal ssp_enable from bus_sampling.vhd",
      swaccess: "rw",
      hwaccess: "hrw",
      fields: [
        {
          name: "value",
          bits: "31:0",
          desc: "Placeholder 32-bit field for extracted signal"
        }
      ]
    },
    {
      name: "bus_traffic_counters_tx_ctr_i",
      desc: "Auto-extracted signal tx_ctr_i from bus_traffic_counters.vhd",
      swaccess: "rw",
      hwaccess: "hrw",
      fields: [
        {
          name: "value",
          bits: "31:0",
          desc: "Placeholder 32-bit field for extracted signal"
        }
      ]
    },
    {
      name: "bus_traffic_counters_rx_ctr_i",
      desc: "Auto-extracted signal rx_ctr_i from bus_traffic_counters.vhd",
      swaccess: "rw",
      hwaccess: "hrw",
      fields: [
        {
          name: "value",
          bits: "31:0",
          desc: "Placeholder 32-bit field for extracted signal"
        }
      ]
    },
    {
      name: "bus_traffic_counters_tx_ctr_rst_n_d",
      desc: "Auto-extracted signal tx_ctr_rst_n_d from bus_traffic_counters.vhd",
      swaccess: "rw",
      hwaccess: "hrw",
      fields: [
        {
          name: "value",
          bits: "31:0",
          desc: "Placeholder 32-bit field for extracted signal"
        }
      ]
    },
    {
      name: "bus_traffic_counters_tx_ctr_rst_n_q",
      desc: "Auto-extracted signal tx_ctr_rst_n_q from bus_traffic_counters.vhd",
      swaccess: "rw",
      hwaccess: "hrw",
      fields: [
        {
          name: "value",
          bits: "31:0",
          desc: "Placeholder 32-bit field for extracted signal"
        }
      ]
    },
    {
      name: "bus_traffic_counters_tx_ctr_rst_n_q_scan",
      desc: "Auto-extracted signal tx_ctr_rst_n_q_scan from bus_traffic_counters.vhd",
      swaccess: "rw",
      hwaccess: "hrw",
      fields: [
        {
          name: "value",
          bits: "31:0",
          desc: "Placeholder 32-bit field for extracted signal"
        }
      ]
    },
    {
      name: "bus_traffic_counters_rx_ctr_rst_n_d",
      desc: "Auto-extracted signal rx_ctr_rst_n_d from bus_traffic_counters.vhd",
      swaccess: "rw",
      hwaccess: "hrw",
      fields: [
        {
          name: "value",
          bits: "31:0",
          desc: "Placeholder 32-bit field for extracted signal"
        }
      ]
    },
    {
      name: "bus_traffic_counters_rx_ctr_rst_n_q",
      desc: "Auto-extracted signal rx_ctr_rst_n_q from bus_traffic_counters.vhd",
      swaccess: "rw",
      hwaccess: "hrw",
      fields: [
        {
          name: "value",
          bits: "31:0",
          desc: "Placeholder 32-bit field for extracted signal"
        }
      ]
    },
    {
      name: "bus_traffic_counters_rx_ctr_rst_n_q_scan",
      desc: "Auto-extracted signal rx_ctr_rst_n_q_scan from bus_traffic_counters.vhd",
      swaccess: "rw",
      hwaccess: "hrw",
      fields: [
        {
          name: "value",
          bits: "31:0",
          desc: "Placeholder 32-bit field for extracted signal"
        }
      ]
    },
    {
      name: "can_apb_tb_s_apb_paddr",
      desc: "Auto-extracted signal s_apb_paddr from can_apb_tb.vhd",
      swaccess: "rw",
      hwaccess: "hrw",
      fields: [
        {
          name: "value",
          bits: "31:0",
          desc: "Placeholder 32-bit field for extracted signal"
        }
      ]
    },
    {
      name: "can_apb_tb_s_apb_penable",
      desc: "Auto-extracted signal s_apb_penable from can_apb_tb.vhd",
      swaccess: "rw",
      hwaccess: "hrw",
      fields: [
        {
          name: "value",
          bits: "31:0",
          desc: "Placeholder 32-bit field for extracted signal"
        }
      ]
    },
    {
      name: "can_apb_tb_s_apb_pprot",
      desc: "Auto-extracted signal s_apb_pprot from can_apb_tb.vhd",
      swaccess: "rw",
      hwaccess: "hrw",
      fields: [
        {
          name: "value",
          bits: "31:0",
          desc: "Placeholder 32-bit field for extracted signal"
        }
      ]
    },
    {
      name: "can_apb_tb_s_apb_prdata",
      desc: "Auto-extracted signal s_apb_prdata from can_apb_tb.vhd",
      swaccess: "rw",
      hwaccess: "hrw",
      fields: [
        {
          name: "value",
          bits: "31:0",
          desc: "Placeholder 32-bit field for extracted signal"
        }
      ]
    },
    {
      name: "can_apb_tb_s_apb_pready",
      desc: "Auto-extracted signal s_apb_pready from can_apb_tb.vhd",
      swaccess: "rw",
      hwaccess: "hrw",
      fields: [
        {
          name: "value",
          bits: "31:0",
          desc: "Placeholder 32-bit field for extracted signal"
        }
      ]
    },
    {
      name: "can_apb_tb_s_apb_psel",
      desc: "Auto-extracted signal s_apb_psel from can_apb_tb.vhd",
      swaccess: "rw",
      hwaccess: "hrw",
      fields: [
        {
          name: "value",
          bits: "31:0",
          desc: "Placeholder 32-bit field for extracted signal"
        }
      ]
    },
    {
      name: "can_apb_tb_s_apb_pslverr",
      desc: "Auto-extracted signal s_apb_pslverr from can_apb_tb.vhd",
      swaccess: "rw",
      hwaccess: "hrw",
      fields: [
        {
          name: "value",
          bits: "31:0",
          desc: "Placeholder 32-bit field for extracted signal"
        }
      ]
    },
    {
      name: "can_apb_tb_s_apb_pstrb",
      desc: "Auto-extracted signal s_apb_pstrb from can_apb_tb.vhd",
      swaccess: "rw",
      hwaccess: "hrw",
      fields: [
        {
          name: "value",
          bits: "31:0",
          desc: "Placeholder 32-bit field for extracted signal"
        }
      ]
    },
    {
      name: "can_apb_tb_s_apb_pwdata",
      desc: "Auto-extracted signal s_apb_pwdata from can_apb_tb.vhd",
      swaccess: "rw",
      hwaccess: "hrw",
      fields: [
        {
          name: "value",
          bits: "31:0",
          desc: "Placeholder 32-bit field for extracted signal"
        }
      ]
    },
    {
      name: "can_apb_tb_s_apb_pwrite",
      desc: "Auto-extracted signal s_apb_pwrite from can_apb_tb.vhd",
      swaccess: "rw",
      hwaccess: "hrw",
      fields: [
        {
          name: "value",
          bits: "31:0",
          desc: "Placeholder 32-bit field for extracted signal"
        }
      ]
    },
    {
      name: "can_core_drv_clr_rx_ctr",
      desc: "Auto-extracted signal drv_clr_rx_ctr from can_core.vhd",
      swaccess: "rw",
      hwaccess: "hrw",
      fields: [
        {
          name: "value",
          bits: "31:0",
          desc: "Placeholder 32-bit field for extracted signal"
        }
      ]
    },
    {
      name: "can_core_drv_clr_tx_ctr",
      desc: "Auto-extracted signal drv_clr_tx_ctr from can_core.vhd",
      swaccess: "rw",
      hwaccess: "hrw",
      fields: [
        {
          name: "value",
          bits: "31:0",
          desc: "Placeholder 32-bit field for extracted signal"
        }
      ]
    },
    {
      name: "can_core_drv_bus_mon_ena",
      desc: "Auto-extracted signal drv_bus_mon_ena from can_core.vhd",
      swaccess: "rw",
      hwaccess: "hrw",
      fields: [
        {
          name: "value",
          bits: "31:0",
          desc: "Placeholder 32-bit field for extracted signal"
        }
      ]
    },
    {
      name: "can_core_drv_ena",
      desc: "Auto-extracted signal drv_ena from can_core.vhd",
      swaccess: "rw",
      hwaccess: "hrw",
      fields: [
        {
          name: "value",
          bits: "31:0",
          desc: "Placeholder 32-bit field for extracted signal"
        }
      ]
    },
    {
      name: "can_core_rec_ident_i",
      desc: "Auto-extracted signal rec_ident_i from can_core.vhd",
      swaccess: "rw",
      hwaccess: "hrw",
      fields: [
        {
          name: "value",
          bits: "31:0",
          desc: "Placeholder 32-bit field for extracted signal"
        }
      ]
    },
    {
      name: "can_core_rec_dlc_i",
      desc: "Auto-extracted signal rec_dlc_i from can_core.vhd",
      swaccess: "rw",
      hwaccess: "hrw",
      fields: [
        {
          name: "value",
          bits: "31:0",
          desc: "Placeholder 32-bit field for extracted signal"
        }
      ]
    },
    {
      name: "can_core_rec_ident_type_i",
      desc: "Auto-extracted signal rec_ident_type_i from can_core.vhd",
      swaccess: "rw",
      hwaccess: "hrw",
      fields: [
        {
          name: "value",
          bits: "31:0",
          desc: "Placeholder 32-bit field for extracted signal"
        }
      ]
    },
    {
      name: "can_core_rec_frame_type_i",
      desc: "Auto-extracted signal rec_frame_type_i from can_core.vhd",
      swaccess: "rw",
      hwaccess: "hrw",
      fields: [
        {
          name: "value",
          bits: "31:0",
          desc: "Placeholder 32-bit field for extracted signal"
        }
      ]
    },
    {
      name: "can_core_rec_is_rtr_i",
      desc: "Auto-extracted signal rec_is_rtr_i from can_core.vhd",
      swaccess: "rw",
      hwaccess: "hrw",
      fields: [
        {
          name: "value",
          bits: "31:0",
          desc: "Placeholder 32-bit field for extracted signal"
        }
      ]
    },
    {
      name: "can_core_rec_brs_i",
      desc: "Auto-extracted signal rec_brs_i from can_core.vhd",
      swaccess: "rw",
      hwaccess: "hrw",
      fields: [
        {
          name: "value",
          bits: "31:0",
          desc: "Placeholder 32-bit field for extracted signal"
        }
      ]
    },
    {
      name: "can_core_rec_esi_i",
      desc: "Auto-extracted signal rec_esi_i from can_core.vhd",
      swaccess: "rw",
      hwaccess: "hrw",
      fields: [
        {
          name: "value",
          bits: "31:0",
          desc: "Placeholder 32-bit field for extracted signal"
        }
      ]
    },
    {
      name: "can_core_alc",
      desc: "Auto-extracted signal alc from can_core.vhd",
      swaccess: "rw",
      hwaccess: "hrw",
      fields: [
        {
          name: "value",
          bits: "31:0",
          desc: "Placeholder 32-bit field for extracted signal"
        }
      ]
    },
    {
      name: "can_core_erc_capture",
      desc: "Auto-extracted signal erc_capture from can_core.vhd",
      swaccess: "rw",
      hwaccess: "hrw",
      fields: [
        {
          name: "value",
          bits: "31:0",
          desc: "Placeholder 32-bit field for extracted signal"
        }
      ]
    },
    {
      name: "can_core_is_transmitter",
      desc: "Auto-extracted signal is_transmitter from can_core.vhd",
      swaccess: "rw",
      hwaccess: "hrw",
      fields: [
        {
          name: "value",
          bits: "31:0",
          desc: "Placeholder 32-bit field for extracted signal"
        }
      ]
    },
    {
      name: "can_core_is_receiver",
      desc: "Auto-extracted signal is_receiver from can_core.vhd",
      swaccess: "rw",
      hwaccess: "hrw",
      fields: [
        {
          name: "value",
          bits: "31:0",
          desc: "Placeholder 32-bit field for extracted signal"
        }
      ]
    },
    {
      name: "can_core_is_idle",
      desc: "Auto-extracted signal is_idle from can_core.vhd",
      swaccess: "rw",
      hwaccess: "hrw",
      fields: [
        {
          name: "value",
          bits: "31:0",
          desc: "Placeholder 32-bit field for extracted signal"
        }
      ]
    },
    {
      name: "can_core_arbitration_lost_i",
      desc: "Auto-extracted signal arbitration_lost_i from can_core.vhd",
      swaccess: "rw",
      hwaccess: "hrw",
      fields: [
        {
          name: "value",
          bits: "31:0",
          desc: "Placeholder 32-bit field for extracted signal"
        }
      ]
    },
    {
      name: "can_core_set_transmitter",
      desc: "Auto-extracted signal set_transmitter from can_core.vhd",
      swaccess: "rw",
      hwaccess: "hrw",
      fields: [
        {
          name: "value",
          bits: "31:0",
          desc: "Placeholder 32-bit field for extracted signal"
        }
      ]
    },
    {
      name: "can_core_set_receiver",
      desc: "Auto-extracted signal set_receiver from can_core.vhd",
      swaccess: "rw",
      hwaccess: "hrw",
      fields: [
        {
          name: "value",
          bits: "31:0",
          desc: "Placeholder 32-bit field for extracted signal"
        }
      ]
    },
    {
      name: "can_core_set_idle",
      desc: "Auto-extracted signal set_idle from can_core.vhd",
      swaccess: "rw",
      hwaccess: "hrw",
      fields: [
        {
          name: "value",
          bits: "31:0",
          desc: "Placeholder 32-bit field for extracted signal"
        }
      ]
    },
    {
      name: "can_core_is_err_active",
      desc: "Auto-extracted signal is_err_active from can_core.vhd",
      swaccess: "rw",
      hwaccess: "hrw",
      fields: [
        {
          name: "value",
          bits: "31:0",
          desc: "Placeholder 32-bit field for extracted signal"
        }
      ]
    },
    {
      name: "can_core_is_err_passive",
      desc: "Auto-extracted signal is_err_passive from can_core.vhd",
      swaccess: "rw",
      hwaccess: "hrw",
      fields: [
        {
          name: "value",
          bits: "31:0",
          desc: "Placeholder 32-bit field for extracted signal"
        }
      ]
    },
    {
      name: "can_core_is_bus_off_i",
      desc: "Auto-extracted signal is_bus_off_i from can_core.vhd",
      swaccess: "rw",
      hwaccess: "hrw",
      fields: [
        {
          name: "value",
          bits: "31:0",
          desc: "Placeholder 32-bit field for extracted signal"
        }
      ]
    },
    {
      name: "can_core_err_detected_i",
      desc: "Auto-extracted signal err_detected_i from can_core.vhd",
      swaccess: "rw",
      hwaccess: "hrw",
      fields: [
        {
          name: "value",
          bits: "31:0",
          desc: "Placeholder 32-bit field for extracted signal"
        }
      ]
    },
    {
      name: "can_core_primary_err",
      desc: "Auto-extracted signal primary_err from can_core.vhd",
      swaccess: "rw",
      hwaccess: "hrw",
      fields: [
        {
          name: "value",
          bits: "31:0",
          desc: "Placeholder 32-bit field for extracted signal"
        }
      ]
    },
    {
      name: "can_core_act_err_ovr_flag",
      desc: "Auto-extracted signal act_err_ovr_flag from can_core.vhd",
      swaccess: "rw",
      hwaccess: "hrw",
      fields: [
        {
          name: "value",
          bits: "31:0",
          desc: "Placeholder 32-bit field for extracted signal"
        }
      ]
    },
    {
      name: "can_core_err_delim_late",
      desc: "Auto-extracted signal err_delim_late from can_core.vhd",
      swaccess: "rw",
      hwaccess: "hrw",
      fields: [
        {
          name: "value",
          bits: "31:0",
          desc: "Placeholder 32-bit field for extracted signal"
        }
      ]
    },
    {
      name: "can_core_set_err_active",
      desc: "Auto-extracted signal set_err_active from can_core.vhd",
      swaccess: "rw",
      hwaccess: "hrw",
      fields: [
        {
          name: "value",
          bits: "31:0",
          desc: "Placeholder 32-bit field for extracted signal"
        }
      ]
    },
    {
      name: "can_core_err_ctrs_unchanged",
      desc: "Auto-extracted signal err_ctrs_unchanged from can_core.vhd",
      swaccess: "rw",
      hwaccess: "hrw",
      fields: [
        {
          name: "value",
          bits: "31:0",
          desc: "Placeholder 32-bit field for extracted signal"
        }
      ]
    },
    {
      name: "can_core_stuff_enable",
      desc: "Auto-extracted signal stuff_enable from can_core.vhd",
      swaccess: "rw",
      hwaccess: "hrw",
      fields: [
        {
          name: "value",
          bits: "31:0",
          desc: "Placeholder 32-bit field for extracted signal"
        }
      ]
    },
    {
      name: "can_core_destuff_enable",
      desc: "Auto-extracted signal destuff_enable from can_core.vhd",
      swaccess: "rw",
      hwaccess: "hrw",
      fields: [
        {
          name: "value",
          bits: "31:0",
          desc: "Placeholder 32-bit field for extracted signal"
        }
      ]
    },
    {
      name: "can_core_fixed_stuff",
      desc: "Auto-extracted signal fixed_stuff from can_core.vhd",
      swaccess: "rw",
      hwaccess: "hrw",
      fields: [
        {
          name: "value",
          bits: "31:0",
          desc: "Placeholder 32-bit field for extracted signal"
        }
      ]
    },
    {
      name: "can_core_tx_frame_no_sof",
      desc: "Auto-extracted signal tx_frame_no_sof from can_core.vhd",
      swaccess: "rw",
      hwaccess: "hrw",
      fields: [
        {
          name: "value",
          bits: "31:0",
          desc: "Placeholder 32-bit field for extracted signal"
        }
      ]
    },
    {
      name: "can_core_stuff_length",
      desc: "Auto-extracted signal stuff_length from can_core.vhd",
      swaccess: "rw",
      hwaccess: "hrw",
      fields: [
        {
          name: "value",
          bits: "31:0",
          desc: "Placeholder 32-bit field for extracted signal"
        }
      ]
    },
    {
      name: "can_core_dst_ctr",
      desc: "Auto-extracted signal dst_ctr from can_core.vhd",
      swaccess: "rw",
      hwaccess: "hrw",
      fields: [
        {
          name: "value",
          bits: "31:0",
          desc: "Placeholder 32-bit field for extracted signal"
        }
      ]
    },
    {
      name: "can_core_bst_ctr",
      desc: "Auto-extracted signal bst_ctr from can_core.vhd",
      swaccess: "rw",
      hwaccess: "hrw",
      fields: [
        {
          name: "value",
          bits: "31:0",
          desc: "Placeholder 32-bit field for extracted signal"
        }
      ]
    },
    {
      name: "can_core_stuff_err",
      desc: "Auto-extracted signal stuff_err from can_core.vhd",
      swaccess: "rw",
      hwaccess: "hrw",
      fields: [
        {
          name: "value",
          bits: "31:0",
          desc: "Placeholder 32-bit field for extracted signal"
        }
      ]
    },
    {
      name: "can_core_crc_enable",
      desc: "Auto-extracted signal crc_enable from can_core.vhd",
      swaccess: "rw",
      hwaccess: "hrw",
      fields: [
        {
          name: "value",
          bits: "31:0",
          desc: "Placeholder 32-bit field for extracted signal"
        }
      ]
    },
    {
      name: "can_core_crc_spec_enable",
      desc: "Auto-extracted signal crc_spec_enable from can_core.vhd",
      swaccess: "rw",
      hwaccess: "hrw",
      fields: [
        {
          name: "value",
          bits: "31:0",
          desc: "Placeholder 32-bit field for extracted signal"
        }
      ]
    },
    {
      name: "can_core_crc_calc_from_rx",
      desc: "Auto-extracted signal crc_calc_from_rx from can_core.vhd",
      swaccess: "rw",
      hwaccess: "hrw",
      fields: [
        {
          name: "value",
          bits: "31:0",
          desc: "Placeholder 32-bit field for extracted signal"
        }
      ]
    },
    {
      name: "can_core_crc_15",
      desc: "Auto-extracted signal crc_15 from can_core.vhd",
      swaccess: "rw",
      hwaccess: "hrw",
      fields: [
        {
          name: "value",
          bits: "31:0",
          desc: "Placeholder 32-bit field for extracted signal"
        }
      ]
    },
    {
      name: "can_core_crc_17",
      desc: "Auto-extracted signal crc_17 from can_core.vhd",
      swaccess: "rw",
      hwaccess: "hrw",
      fields: [
        {
          name: "value",
          bits: "31:0",
          desc: "Placeholder 32-bit field for extracted signal"
        }
      ]
    },
    {
      name: "can_core_crc_21",
      desc: "Auto-extracted signal crc_21 from can_core.vhd",
      swaccess: "rw",
      hwaccess: "hrw",
      fields: [
        {
          name: "value",
          bits: "31:0",
          desc: "Placeholder 32-bit field for extracted signal"
        }
      ]
    },
    {
      name: "can_core_sp_control_i",
      desc: "Auto-extracted signal sp_control_i from can_core.vhd",
      swaccess: "rw",
      hwaccess: "hrw",
      fields: [
        {
          name: "value",
          bits: "31:0",
          desc: "Placeholder 32-bit field for extracted signal"
        }
      ]
    },
    {
      name: "can_core_sp_control_q",
      desc: "Auto-extracted signal sp_control_q from can_core.vhd",
      swaccess: "rw",
      hwaccess: "hrw",
      fields: [
        {
          name: "value",
          bits: "31:0",
          desc: "Placeholder 32-bit field for extracted signal"
        }
      ]
    },
    {
      name: "can_core_sync_control_i",
      desc: "Auto-extracted signal sync_control_i from can_core.vhd",
      swaccess: "rw",
      hwaccess: "hrw",
      fields: [
        {
          name: "value",
          bits: "31:0",
          desc: "Placeholder 32-bit field for extracted signal"
        }
      ]
    },
    {
      name: "can_core_ssp_reset_i",
      desc: "Auto-extracted signal ssp_reset_i from can_core.vhd",
      swaccess: "rw",
      hwaccess: "hrw",
      fields: [
        {
          name: "value",
          bits: "31:0",
          desc: "Placeholder 32-bit field for extracted signal"
        }
      ]
    },
    {
      name: "can_core_tran_delay_meas_i",
      desc: "Auto-extracted signal tran_delay_meas_i from can_core.vhd",
      swaccess: "rw",
      hwaccess: "hrw",
      fields: [
        {
          name: "value",
          bits: "31:0",
          desc: "Placeholder 32-bit field for extracted signal"
        }
      ]
    },
    {
      name: "can_core_tran_valid_i",
      desc: "Auto-extracted signal tran_valid_i from can_core.vhd",
      swaccess: "rw",
      hwaccess: "hrw",
      fields: [
        {
          name: "value",
          bits: "31:0",
          desc: "Placeholder 32-bit field for extracted signal"
        }
      ]
    },
    {
      name: "can_core_rec_valid_i",
      desc: "Auto-extracted signal rec_valid_i from can_core.vhd",
      swaccess: "rw",
      hwaccess: "hrw",
      fields: [
        {
          name: "value",
          bits: "31:0",
          desc: "Placeholder 32-bit field for extracted signal"
        }
      ]
    },
    {
      name: "can_core_br_shifted_i",
      desc: "Auto-extracted signal br_shifted_i from can_core.vhd",
      swaccess: "rw",
      hwaccess: "hrw",
      fields: [
        {
          name: "value",
          bits: "31:0",
          desc: "Placeholder 32-bit field for extracted signal"
        }
      ]
    },
    {
      name: "can_core_fcs_changed_i",
      desc: "Auto-extracted signal fcs_changed_i from can_core.vhd",
      swaccess: "rw",
      hwaccess: "hrw",
      fields: [
        {
          name: "value",
          bits: "31:0",
          desc: "Placeholder 32-bit field for extracted signal"
        }
      ]
    },
    {
      name: "can_core_err_warning_limit_i",
      desc: "Auto-extracted signal err_warning_limit_i from can_core.vhd",
      swaccess: "rw",
      hwaccess: "hrw",
      fields: [
        {
          name: "value",
          bits: "31:0",
          desc: "Placeholder 32-bit field for extracted signal"
        }
      ]
    },
    {
      name: "can_core_tx_err_ctr",
      desc: "Auto-extracted signal tx_err_ctr from can_core.vhd",
      swaccess: "rw",
      hwaccess: "hrw",
      fields: [
        {
          name: "value",
          bits: "31:0",
          desc: "Placeholder 32-bit field for extracted signal"
        }
      ]
    },
    {
      name: "can_core_rx_err_ctr",
      desc: "Auto-extracted signal rx_err_ctr from can_core.vhd",
      swaccess: "rw",
      hwaccess: "hrw",
      fields: [
        {
          name: "value",
          bits: "31:0",
          desc: "Placeholder 32-bit field for extracted signal"
        }
      ]
    },
    {
      name: "can_core_norm_err_ctr",
      desc: "Auto-extracted signal norm_err_ctr from can_core.vhd",
      swaccess: "rw",
      hwaccess: "hrw",
      fields: [
        {
          name: "value",
          bits: "31:0",
          desc: "Placeholder 32-bit field for extracted signal"
        }
      ]
    },
    {
      name: "can_core_data_err_ctr",
      desc: "Auto-extracted signal data_err_ctr from can_core.vhd",
      swaccess: "rw",
      hwaccess: "hrw",
      fields: [
        {
          name: "value",
          bits: "31:0",
          desc: "Placeholder 32-bit field for extracted signal"
        }
      ]
    },
    {
      name: "can_core_pc_tx_trigger",
      desc: "Auto-extracted signal pc_tx_trigger from can_core.vhd",
      swaccess: "rw",
      hwaccess: "hrw",
      fields: [
        {
          name: "value",
          bits: "31:0",
          desc: "Placeholder 32-bit field for extracted signal"
        }
      ]
    },
    {
      name: "can_core_pc_rx_trigger",
      desc: "Auto-extracted signal pc_rx_trigger from can_core.vhd",
      swaccess: "rw",
      hwaccess: "hrw",
      fields: [
        {
          name: "value",
          bits: "31:0",
          desc: "Placeholder 32-bit field for extracted signal"
        }
      ]
    },
    {
      name: "can_core_pc_tx_data_nbs",
      desc: "Auto-extracted signal pc_tx_data_nbs from can_core.vhd",
      swaccess: "rw",
      hwaccess: "hrw",
      fields: [
        {
          name: "value",
          bits: "31:0",
          desc: "Placeholder 32-bit field for extracted signal"
        }
      ]
    },
    {
      name: "can_core_pc_rx_data_nbs",
      desc: "Auto-extracted signal pc_rx_data_nbs from can_core.vhd",
      swaccess: "rw",
      hwaccess: "hrw",
      fields: [
        {
          name: "value",
          bits: "31:0",
          desc: "Placeholder 32-bit field for extracted signal"
        }
      ]
    },
    {
      name: "can_core_crc_data_tx_wbs",
      desc: "Auto-extracted signal crc_data_tx_wbs from can_core.vhd",
      swaccess: "rw",
      hwaccess: "hrw",
      fields: [
        {
          name: "value",
          bits: "31:0",
          desc: "Placeholder 32-bit field for extracted signal"
        }
      ]
    },
    {
      name: "can_core_crc_data_tx_nbs",
      desc: "Auto-extracted signal crc_data_tx_nbs from can_core.vhd",
      swaccess: "rw",
      hwaccess: "hrw",
      fields: [
        {
          name: "value",
          bits: "31:0",
          desc: "Placeholder 32-bit field for extracted signal"
        }
      ]
    },
    {
      name: "can_core_crc_data_rx_wbs",
      desc: "Auto-extracted signal crc_data_rx_wbs from can_core.vhd",
      swaccess: "rw",
      hwaccess: "hrw",
      fields: [
        {
          name: "value",
          bits: "31:0",
          desc: "Placeholder 32-bit field for extracted signal"
        }
      ]
    },
    {
      name: "can_core_crc_data_rx_nbs",
      desc: "Auto-extracted signal crc_data_rx_nbs from can_core.vhd",
      swaccess: "rw",
      hwaccess: "hrw",
      fields: [
        {
          name: "value",
          bits: "31:0",
          desc: "Placeholder 32-bit field for extracted signal"
        }
      ]
    },
    {
      name: "can_core_crc_trig_tx_wbs",
      desc: "Auto-extracted signal crc_trig_tx_wbs from can_core.vhd",
      swaccess: "rw",
      hwaccess: "hrw",
      fields: [
        {
          name: "value",
          bits: "31:0",
          desc: "Placeholder 32-bit field for extracted signal"
        }
      ]
    },
    {
      name: "can_core_crc_trig_tx_nbs",
      desc: "Auto-extracted signal crc_trig_tx_nbs from can_core.vhd",
      swaccess: "rw",
      hwaccess: "hrw",
      fields: [
        {
          name: "value",
          bits: "31:0",
          desc: "Placeholder 32-bit field for extracted signal"
        }
      ]
    },
    {
      name: "can_core_crc_trig_rx_wbs",
      desc: "Auto-extracted signal crc_trig_rx_wbs from can_core.vhd",
      swaccess: "rw",
      hwaccess: "hrw",
      fields: [
        {
          name: "value",
          bits: "31:0",
          desc: "Placeholder 32-bit field for extracted signal"
        }
      ]
    },
    {
      name: "can_core_crc_trig_rx_nbs",
      desc: "Auto-extracted signal crc_trig_rx_nbs from can_core.vhd",
      swaccess: "rw",
      hwaccess: "hrw",
      fields: [
        {
          name: "value",
          bits: "31:0",
          desc: "Placeholder 32-bit field for extracted signal"
        }
      ]
    },
    {
      name: "can_core_bst_data_in",
      desc: "Auto-extracted signal bst_data_in from can_core.vhd",
      swaccess: "rw",
      hwaccess: "hrw",
      fields: [
        {
          name: "value",
          bits: "31:0",
          desc: "Placeholder 32-bit field for extracted signal"
        }
      ]
    },
    {
      name: "can_core_bst_data_out",
      desc: "Auto-extracted signal bst_data_out from can_core.vhd",
      swaccess: "rw",
      hwaccess: "hrw",
      fields: [
        {
          name: "value",
          bits: "31:0",
          desc: "Placeholder 32-bit field for extracted signal"
        }
      ]
    },
    {
      name: "can_core_bst_trigger",
      desc: "Auto-extracted signal bst_trigger from can_core.vhd",
      swaccess: "rw",
      hwaccess: "hrw",
      fields: [
        {
          name: "value",
          bits: "31:0",
          desc: "Placeholder 32-bit field for extracted signal"
        }
      ]
    },
    {
      name: "can_core_data_halt",
      desc: "Auto-extracted signal data_halt from can_core.vhd",
      swaccess: "rw",
      hwaccess: "hrw",
      fields: [
        {
          name: "value",
          bits: "31:0",
          desc: "Placeholder 32-bit field for extracted signal"
        }
      ]
    },
    {
      name: "can_core_bds_data_in",
      desc: "Auto-extracted signal bds_data_in from can_core.vhd",
      swaccess: "rw",
      hwaccess: "hrw",
      fields: [
        {
          name: "value",
          bits: "31:0",
          desc: "Placeholder 32-bit field for extracted signal"
        }
      ]
    },
    {
      name: "can_core_bds_data_out",
      desc: "Auto-extracted signal bds_data_out from can_core.vhd",
      swaccess: "rw",
      hwaccess: "hrw",
      fields: [
        {
          name: "value",
          bits: "31:0",
          desc: "Placeholder 32-bit field for extracted signal"
        }
      ]
    },
    {
      name: "can_core_bds_trigger",
      desc: "Auto-extracted signal bds_trigger from can_core.vhd",
      swaccess: "rw",
      hwaccess: "hrw",
      fields: [
        {
          name: "value",
          bits: "31:0",
          desc: "Placeholder 32-bit field for extracted signal"
        }
      ]
    },
    {
      name: "can_core_destuffed",
      desc: "Auto-extracted signal destuffed from can_core.vhd",
      swaccess: "rw",
      hwaccess: "hrw",
      fields: [
        {
          name: "value",
          bits: "31:0",
          desc: "Placeholder 32-bit field for extracted signal"
        }
      ]
    },
    {
      name: "can_core_tx_ctr",
      desc: "Auto-extracted signal tx_ctr from can_core.vhd",
      swaccess: "rw",
      hwaccess: "hrw",
      fields: [
        {
          name: "value",
          bits: "31:0",
          desc: "Placeholder 32-bit field for extracted signal"
        }
      ]
    },
    {
      name: "can_core_rx_ctr",
      desc: "Auto-extracted signal rx_ctr from can_core.vhd",
      swaccess: "rw",
      hwaccess: "hrw",
      fields: [
        {
          name: "value",
          bits: "31:0",
          desc: "Placeholder 32-bit field for extracted signal"
        }
      ]
    },
    {
      name: "can_core_tx_data_wbs_i",
      desc: "Auto-extracted signal tx_data_wbs_i from can_core.vhd",
      swaccess: "rw",
      hwaccess: "hrw",
      fields: [
        {
          name: "value",
          bits: "31:0",
          desc: "Placeholder 32-bit field for extracted signal"
        }
      ]
    },
    {
      name: "can_core_lpb_dominant",
      desc: "Auto-extracted signal lpb_dominant from can_core.vhd",
      swaccess: "rw",
      hwaccess: "hrw",
      fields: [
        {
          name: "value",
          bits: "31:0",
          desc: "Placeholder 32-bit field for extracted signal"
        }
      ]
    },
    {
      name: "can_core_form_err",
      desc: "Auto-extracted signal form_err from can_core.vhd",
      swaccess: "rw",
      hwaccess: "hrw",
      fields: [
        {
          name: "value",
          bits: "31:0",
          desc: "Placeholder 32-bit field for extracted signal"
        }
      ]
    },
    {
      name: "can_core_ack_err",
      desc: "Auto-extracted signal ack_err from can_core.vhd",
      swaccess: "rw",
      hwaccess: "hrw",
      fields: [
        {
          name: "value",
          bits: "31:0",
          desc: "Placeholder 32-bit field for extracted signal"
        }
      ]
    },
    {
      name: "can_core_crc_err",
      desc: "Auto-extracted signal crc_err from can_core.vhd",
      swaccess: "rw",
      hwaccess: "hrw",
      fields: [
        {
          name: "value",
          bits: "31:0",
          desc: "Placeholder 32-bit field for extracted signal"
        }
      ]
    },
    {
      name: "can_core_is_arbitration",
      desc: "Auto-extracted signal is_arbitration from can_core.vhd",
      swaccess: "rw",
      hwaccess: "hrw",
      fields: [
        {
          name: "value",
          bits: "31:0",
          desc: "Placeholder 32-bit field for extracted signal"
        }
      ]
    },
    {
      name: "can_core_is_control",
      desc: "Auto-extracted signal is_control from can_core.vhd",
      swaccess: "rw",
      hwaccess: "hrw",
      fields: [
        {
          name: "value",
          bits: "31:0",
          desc: "Placeholder 32-bit field for extracted signal"
        }
      ]
    },
    {
      name: "can_core_is_data",
      desc: "Auto-extracted signal is_data from can_core.vhd",
      swaccess: "rw",
      hwaccess: "hrw",
      fields: [
        {
          name: "value",
          bits: "31:0",
          desc: "Placeholder 32-bit field for extracted signal"
        }
      ]
    },
    {
      name: "can_core_is_stuff_count",
      desc: "Auto-extracted signal is_stuff_count from can_core.vhd",
      swaccess: "rw",
      hwaccess: "hrw",
      fields: [
        {
          name: "value",
          bits: "31:0",
          desc: "Placeholder 32-bit field for extracted signal"
        }
      ]
    },
    {
      name: "can_core_is_crc",
      desc: "Auto-extracted signal is_crc from can_core.vhd",
      swaccess: "rw",
      hwaccess: "hrw",
      fields: [
        {
          name: "value",
          bits: "31:0",
          desc: "Placeholder 32-bit field for extracted signal"
        }
      ]
    },
    {
      name: "can_core_is_crc_delim",
      desc: "Auto-extracted signal is_crc_delim from can_core.vhd",
      swaccess: "rw",
      hwaccess: "hrw",
      fields: [
        {
          name: "value",
          bits: "31:0",
          desc: "Placeholder 32-bit field for extracted signal"
        }
      ]
    },
    {
      name: "can_core_is_ack_field",
      desc: "Auto-extracted signal is_ack_field from can_core.vhd",
      swaccess: "rw",
      hwaccess: "hrw",
      fields: [
        {
          name: "value",
          bits: "31:0",
          desc: "Placeholder 32-bit field for extracted signal"
        }
      ]
    },
    {
      name: "can_core_is_ack_delim",
      desc: "Auto-extracted signal is_ack_delim from can_core.vhd",
      swaccess: "rw",
      hwaccess: "hrw",
      fields: [
        {
          name: "value",
          bits: "31:0",
          desc: "Placeholder 32-bit field for extracted signal"
        }
      ]
    },
    {
      name: "can_core_is_eof",
      desc: "Auto-extracted signal is_eof from can_core.vhd",
      swaccess: "rw",
      hwaccess: "hrw",
      fields: [
        {
          name: "value",
          bits: "31:0",
          desc: "Placeholder 32-bit field for extracted signal"
        }
      ]
    },
    {
      name: "can_core_is_err_frm",
      desc: "Auto-extracted signal is_err_frm from can_core.vhd",
      swaccess: "rw",
      hwaccess: "hrw",
      fields: [
        {
          name: "value",
          bits: "31:0",
          desc: "Placeholder 32-bit field for extracted signal"
        }
      ]
    },
    {
      name: "can_core_is_intermission",
      desc: "Auto-extracted signal is_intermission from can_core.vhd",
      swaccess: "rw",
      hwaccess: "hrw",
      fields: [
        {
          name: "value",
          bits: "31:0",
          desc: "Placeholder 32-bit field for extracted signal"
        }
      ]
    },
    {
      name: "can_core_is_suspend",
      desc: "Auto-extracted signal is_suspend from can_core.vhd",
      swaccess: "rw",
      hwaccess: "hrw",
      fields: [
        {
          name: "value",
          bits: "31:0",
          desc: "Placeholder 32-bit field for extracted signal"
        }
      ]
    },
    {
      name: "can_core_is_overload_i",
      desc: "Auto-extracted signal is_overload_i from can_core.vhd",
      swaccess: "rw",
      hwaccess: "hrw",
      fields: [
        {
          name: "value",
          bits: "31:0",
          desc: "Placeholder 32-bit field for extracted signal"
        }
      ]
    },
    {
      name: "can_core_is_sof",
      desc: "Auto-extracted signal is_sof from can_core.vhd",
      swaccess: "rw",
      hwaccess: "hrw",
      fields: [
        {
          name: "value",
          bits: "31:0",
          desc: "Placeholder 32-bit field for extracted signal"
        }
      ]
    },
    {
      name: "can_core_sof_pulse_i",
      desc: "Auto-extracted signal sof_pulse_i from can_core.vhd",
      swaccess: "rw",
      hwaccess: "hrw",
      fields: [
        {
          name: "value",
          bits: "31:0",
          desc: "Placeholder 32-bit field for extracted signal"
        }
      ]
    },
    {
      name: "can_core_load_init_vect",
      desc: "Auto-extracted signal load_init_vect from can_core.vhd",
      swaccess: "rw",
      hwaccess: "hrw",
      fields: [
        {
          name: "value",
          bits: "31:0",
          desc: "Placeholder 32-bit field for extracted signal"
        }
      ]
    },
    {
      name: "can_core_retr_ctr_i",
      desc: "Auto-extracted signal retr_ctr_i from can_core.vhd",
      swaccess: "rw",
      hwaccess: "hrw",
      fields: [
        {
          name: "value",
          bits: "31:0",
          desc: "Placeholder 32-bit field for extracted signal"
        }
      ]
    },
    {
      name: "can_core_decrement_rec",
      desc: "Auto-extracted signal decrement_rec from can_core.vhd",
      swaccess: "rw",
      hwaccess: "hrw",
      fields: [
        {
          name: "value",
          bits: "31:0",
          desc: "Placeholder 32-bit field for extracted signal"
        }
      ]
    },
    {
      name: "can_core_bit_err_after_ack_err",
      desc: "Auto-extracted signal bit_err_after_ack_err from can_core.vhd",
      swaccess: "rw",
      hwaccess: "hrw",
      fields: [
        {
          name: "value",
          bits: "31:0",
          desc: "Placeholder 32-bit field for extracted signal"
        }
      ]
    },
    {
      name: "can_core_is_pexs",
      desc: "Auto-extracted signal is_pexs from can_core.vhd",
      swaccess: "rw",
      hwaccess: "hrw",
      fields: [
        {
          name: "value",
          bits: "31:0",
          desc: "Placeholder 32-bit field for extracted signal"
        }
      ]
    },
    {
      name: "can_crc_drv_fd_type",
      desc: "Auto-extracted signal drv_fd_type from can_crc.vhd",
      swaccess: "rw",
      hwaccess: "hrw",
      fields: [
        {
          name: "value",
          bits: "31:0",
          desc: "Placeholder 32-bit field for extracted signal"
        }
      ]
    },
    {
      name: "can_crc_init_vect_15",
      desc: "Auto-extracted signal init_vect_15 from can_crc.vhd",
      swaccess: "rw",
      hwaccess: "hrw",
      fields: [
        {
          name: "value",
          bits: "31:0",
          desc: "Placeholder 32-bit field for extracted signal"
        }
      ]
    },
    {
      name: "can_crc_init_vect_17",
      desc: "Auto-extracted signal init_vect_17 from can_crc.vhd",
      swaccess: "rw",
      hwaccess: "hrw",
      fields: [
        {
          name: "value",
          bits: "31:0",
          desc: "Placeholder 32-bit field for extracted signal"
        }
      ]
    },
    {
      name: "can_crc_init_vect_21",
      desc: "Auto-extracted signal init_vect_21 from can_crc.vhd",
      swaccess: "rw",
      hwaccess: "hrw",
      fields: [
        {
          name: "value",
          bits: "31:0",
          desc: "Placeholder 32-bit field for extracted signal"
        }
      ]
    },
    {
      name: "can_crc_crc_17_21_data_in",
      desc: "Auto-extracted signal crc_17_21_data_in from can_crc.vhd",
      swaccess: "rw",
      hwaccess: "hrw",
      fields: [
        {
          name: "value",
          bits: "31:0",
          desc: "Placeholder 32-bit field for extracted signal"
        }
      ]
    },
    {
      name: "can_crc_crc_17_21_trigger",
      desc: "Auto-extracted signal crc_17_21_trigger from can_crc.vhd",
      swaccess: "rw",
      hwaccess: "hrw",
      fields: [
        {
          name: "value",
          bits: "31:0",
          desc: "Placeholder 32-bit field for extracted signal"
        }
      ]
    },
    {
      name: "can_crc_crc_15_data_in",
      desc: "Auto-extracted signal crc_15_data_in from can_crc.vhd",
      swaccess: "rw",
      hwaccess: "hrw",
      fields: [
        {
          name: "value",
          bits: "31:0",
          desc: "Placeholder 32-bit field for extracted signal"
        }
      ]
    },
    {
      name: "can_crc_crc_15_trigger",
      desc: "Auto-extracted signal crc_15_trigger from can_crc.vhd",
      swaccess: "rw",
      hwaccess: "hrw",
      fields: [
        {
          name: "value",
          bits: "31:0",
          desc: "Placeholder 32-bit field for extracted signal"
        }
      ]
    },
    {
      name: "can_crc_crc_ena_15",
      desc: "Auto-extracted signal crc_ena_15 from can_crc.vhd",
      swaccess: "rw",
      hwaccess: "hrw",
      fields: [
        {
          name: "value",
          bits: "31:0",
          desc: "Placeholder 32-bit field for extracted signal"
        }
      ]
    },
    {
      name: "can_crc_crc_ena_17_21",
      desc: "Auto-extracted signal crc_ena_17_21 from can_crc.vhd",
      swaccess: "rw",
      hwaccess: "hrw",
      fields: [
        {
          name: "value",
          bits: "31:0",
          desc: "Placeholder 32-bit field for extracted signal"
        }
      ]
    },
    {
      name: "can_top_ahb_ctu_can_data_in",
      desc: "Auto-extracted signal ctu_can_data_in from can_top_ahb.vhd",
      swaccess: "rw",
      hwaccess: "hrw",
      fields: [
        {
          name: "value",
          bits: "31:0",
          desc: "Placeholder 32-bit field for extracted signal"
        }
      ]
    },
    {
      name: "can_top_ahb_ctu_can_data_out",
      desc: "Auto-extracted signal ctu_can_data_out from can_top_ahb.vhd",
      swaccess: "rw",
      hwaccess: "hrw",
      fields: [
        {
          name: "value",
          bits: "31:0",
          desc: "Placeholder 32-bit field for extracted signal"
        }
      ]
    },
    {
      name: "can_top_ahb_ctu_can_adress",
      desc: "Auto-extracted signal ctu_can_adress from can_top_ahb.vhd",
      swaccess: "rw",
      hwaccess: "hrw",
      fields: [
        {
          name: "value",
          bits: "31:0",
          desc: "Placeholder 32-bit field for extracted signal"
        }
      ]
    },
    {
      name: "can_top_ahb_ctu_can_scs",
      desc: "Auto-extracted signal ctu_can_scs from can_top_ahb.vhd",
      swaccess: "rw",
      hwaccess: "hrw",
      fields: [
        {
          name: "value",
          bits: "31:0",
          desc: "Placeholder 32-bit field for extracted signal"
        }
      ]
    },
    {
      name: "can_top_ahb_ctu_can_srd",
      desc: "Auto-extracted signal ctu_can_srd from can_top_ahb.vhd",
      swaccess: "rw",
      hwaccess: "hrw",
      fields: [
        {
          name: "value",
          bits: "31:0",
          desc: "Placeholder 32-bit field for extracted signal"
        }
      ]
    },
    {
      name: "can_top_ahb_ctu_can_swr",
      desc: "Auto-extracted signal ctu_can_swr from can_top_ahb.vhd",
      swaccess: "rw",
      hwaccess: "hrw",
      fields: [
        {
          name: "value",
          bits: "31:0",
          desc: "Placeholder 32-bit field for extracted signal"
        }
      ]
    },
    {
      name: "can_top_ahb_ctu_can_sbe",
      desc: "Auto-extracted signal ctu_can_sbe from can_top_ahb.vhd",
      swaccess: "rw",
      hwaccess: "hrw",
      fields: [
        {
          name: "value",
          bits: "31:0",
          desc: "Placeholder 32-bit field for extracted signal"
        }
      ]
    },
    {
      name: "can_top_ahb_res_n_out_i",
      desc: "Auto-extracted signal res_n_out_i from can_top_ahb.vhd",
      swaccess: "rw",
      hwaccess: "hrw",
      fields: [
        {
          name: "value",
          bits: "31:0",
          desc: "Placeholder 32-bit field for extracted signal"
        }
      ]
    },
    {
      name: "can_top_apb_reg_data_in",
      desc: "Auto-extracted signal reg_data_in from can_top_apb.vhd",
      swaccess: "rw",
      hwaccess: "hrw",
      fields: [
        {
          name: "value",
          bits: "31:0",
          desc: "Placeholder 32-bit field for extracted signal"
        }
      ]
    },
    {
      name: "can_top_apb_reg_data_out",
      desc: "Auto-extracted signal reg_data_out from can_top_apb.vhd",
      swaccess: "rw",
      hwaccess: "hrw",
      fields: [
        {
          name: "value",
          bits: "31:0",
          desc: "Placeholder 32-bit field for extracted signal"
        }
      ]
    },
    {
      name: "can_top_apb_reg_addr",
      desc: "Auto-extracted signal reg_addr from can_top_apb.vhd",
      swaccess: "rw",
      hwaccess: "hrw",
      fields: [
        {
          name: "value",
          bits: "31:0",
          desc: "Placeholder 32-bit field for extracted signal"
        }
      ]
    },
    {
      name: "can_top_apb_reg_be",
      desc: "Auto-extracted signal reg_be from can_top_apb.vhd",
      swaccess: "rw",
      hwaccess: "hrw",
      fields: [
        {
          name: "value",
          bits: "31:0",
          desc: "Placeholder 32-bit field for extracted signal"
        }
      ]
    },
    {
      name: "can_top_apb_reg_rden",
      desc: "Auto-extracted signal reg_rden from can_top_apb.vhd",
      swaccess: "rw",
      hwaccess: "hrw",
      fields: [
        {
          name: "value",
          bits: "31:0",
          desc: "Placeholder 32-bit field for extracted signal"
        }
      ]
    },
    {
      name: "can_top_apb_reg_wren",
      desc: "Auto-extracted signal reg_wren from can_top_apb.vhd",
      swaccess: "rw",
      hwaccess: "hrw",
      fields: [
        {
          name: "value",
          bits: "31:0",
          desc: "Placeholder 32-bit field for extracted signal"
        }
      ]
    },
    {
      name: "can_top_level_drv_bus",
      desc: "Auto-extracted signal drv_bus from can_top_level.vhd",
      swaccess: "rw",
      hwaccess: "hrw",
      fields: [
        {
          name: "value",
          bits: "31:0",
          desc: "Placeholder 32-bit field for extracted signal"
        }
      ]
    },
    {
      name: "can_top_level_stat_bus",
      desc: "Auto-extracted signal stat_bus from can_top_level.vhd",
      swaccess: "rw",
      hwaccess: "hrw",
      fields: [
        {
          name: "value",
          bits: "31:0",
          desc: "Placeholder 32-bit field for extracted signal"
        }
      ]
    },
    {
      name: "can_top_level_res_n_sync",
      desc: "Auto-extracted signal res_n_sync from can_top_level.vhd",
      swaccess: "rw",
      hwaccess: "hrw",
      fields: [
        {
          name: "value",
          bits: "31:0",
          desc: "Placeholder 32-bit field for extracted signal"
        }
      ]
    },
    {
      name: "can_top_level_res_core_n",
      desc: "Auto-extracted signal res_core_n from can_top_level.vhd",
      swaccess: "rw",
      hwaccess: "hrw",
      fields: [
        {
          name: "value",
          bits: "31:0",
          desc: "Placeholder 32-bit field for extracted signal"
        }
      ]
    },
    {
      name: "can_top_level_res_soft_n",
      desc: "Auto-extracted signal res_soft_n from can_top_level.vhd",
      swaccess: "rw",
      hwaccess: "hrw",
      fields: [
        {
          name: "value",
          bits: "31:0",
          desc: "Placeholder 32-bit field for extracted signal"
        }
      ]
    },
    {
      name: "can_top_level_sp_control",
      desc: "Auto-extracted signal sp_control from can_top_level.vhd",
      swaccess: "rw",
      hwaccess: "hrw",
      fields: [
        {
          name: "value",
          bits: "31:0",
          desc: "Placeholder 32-bit field for extracted signal"
        }
      ]
    },
    {
      name: "can_top_level_rx_buf_size",
      desc: "Auto-extracted signal rx_buf_size from can_top_level.vhd",
      swaccess: "rw",
      hwaccess: "hrw",
      fields: [
        {
          name: "value",
          bits: "31:0",
          desc: "Placeholder 32-bit field for extracted signal"
        }
      ]
    },
    {
      name: "can_top_level_rx_full",
      desc: "Auto-extracted signal rx_full from can_top_level.vhd",
      swaccess: "rw",
      hwaccess: "hrw",
      fields: [
        {
          name: "value",
          bits: "31:0",
          desc: "Placeholder 32-bit field for extracted signal"
        }
      ]
    },
    {
      name: "can_top_level_rx_empty",
      desc: "Auto-extracted signal rx_empty from can_top_level.vhd",
      swaccess: "rw",
      hwaccess: "hrw",
      fields: [
        {
          name: "value",
          bits: "31:0",
          desc: "Placeholder 32-bit field for extracted signal"
        }
      ]
    },
    {
      name: "can_top_level_rx_frame_count",
      desc: "Auto-extracted signal rx_frame_count from can_top_level.vhd",
      swaccess: "rw",
      hwaccess: "hrw",
      fields: [
        {
          name: "value",
          bits: "31:0",
          desc: "Placeholder 32-bit field for extracted signal"
        }
      ]
    },
    {
      name: "can_top_level_rx_mem_free",
      desc: "Auto-extracted signal rx_mem_free from can_top_level.vhd",
      swaccess: "rw",
      hwaccess: "hrw",
      fields: [
        {
          name: "value",
          bits: "31:0",
          desc: "Placeholder 32-bit field for extracted signal"
        }
      ]
    },
    {
      name: "can_top_level_rx_read_pointer",
      desc: "Auto-extracted signal rx_read_pointer from can_top_level.vhd",
      swaccess: "rw",
      hwaccess: "hrw",
      fields: [
        {
          name: "value",
          bits: "31:0",
          desc: "Placeholder 32-bit field for extracted signal"
        }
      ]
    },
    {
      name: "can_top_level_rx_write_pointer",
      desc: "Auto-extracted signal rx_write_pointer from can_top_level.vhd",
      swaccess: "rw",
      hwaccess: "hrw",
      fields: [
        {
          name: "value",
          bits: "31:0",
          desc: "Placeholder 32-bit field for extracted signal"
        }
      ]
    },
    {
      name: "can_top_level_rx_data_overrun",
      desc: "Auto-extracted signal rx_data_overrun from can_top_level.vhd",
      swaccess: "rw",
      hwaccess: "hrw",
      fields: [
        {
          name: "value",
          bits: "31:0",
          desc: "Placeholder 32-bit field for extracted signal"
        }
      ]
    },
    {
      name: "can_top_level_rx_read_buff",
      desc: "Auto-extracted signal rx_read_buff from can_top_level.vhd",
      swaccess: "rw",
      hwaccess: "hrw",
      fields: [
        {
          name: "value",
          bits: "31:0",
          desc: "Placeholder 32-bit field for extracted signal"
        }
      ]
    },
    {
      name: "can_top_level_rx_mof",
      desc: "Auto-extracted signal rx_mof from can_top_level.vhd",
      swaccess: "rw",
      hwaccess: "hrw",
      fields: [
        {
          name: "value",
          bits: "31:0",
          desc: "Placeholder 32-bit field for extracted signal"
        }
      ]
    },
    {
      name: "can_top_level_txtb_port_a_data",
      desc: "Auto-extracted signal txtb_port_a_data from can_top_level.vhd",
      swaccess: "rw",
      hwaccess: "hrw",
      fields: [
        {
          name: "value",
          bits: "31:0",
          desc: "Placeholder 32-bit field for extracted signal"
        }
      ]
    },
    {
      name: "can_top_level_txtb_port_a_address",
      desc: "Auto-extracted signal txtb_port_a_address from can_top_level.vhd",
      swaccess: "rw",
      hwaccess: "hrw",
      fields: [
        {
          name: "value",
          bits: "31:0",
          desc: "Placeholder 32-bit field for extracted signal"
        }
      ]
    },
    {
      name: "can_top_level_txtb_port_a_cs",
      desc: "Auto-extracted signal txtb_port_a_cs from can_top_level.vhd",
      swaccess: "rw",
      hwaccess: "hrw",
      fields: [
        {
          name: "value",
          bits: "31:0",
          desc: "Placeholder 32-bit field for extracted signal"
        }
      ]
    },
    {
      name: "can_top_level_txtb_port_a_be",
      desc: "Auto-extracted signal txtb_port_a_be from can_top_level.vhd",
      swaccess: "rw",
      hwaccess: "hrw",
      fields: [
        {
          name: "value",
          bits: "31:0",
          desc: "Placeholder 32-bit field for extracted signal"
        }
      ]
    },
    {
      name: "can_top_level_txtb_sw_cmd_index",
      desc: "Auto-extracted signal txtb_sw_cmd_index from can_top_level.vhd",
      swaccess: "rw",
      hwaccess: "hrw",
      fields: [
        {
          name: "value",
          bits: "31:0",
          desc: "Placeholder 32-bit field for extracted signal"
        }
      ]
    },
    {
      name: "can_top_level_txt_buf_failed_bof",
      desc: "Auto-extracted signal txt_buf_failed_bof from can_top_level.vhd",
      swaccess: "rw",
      hwaccess: "hrw",
      fields: [
        {
          name: "value",
          bits: "31:0",
          desc: "Placeholder 32-bit field for extracted signal"
        }
      ]
    },
    {
      name: "can_top_level_int_vector",
      desc: "Auto-extracted signal int_vector from can_top_level.vhd",
      swaccess: "rw",
      hwaccess: "hrw",
      fields: [
        {
          name: "value",
          bits: "31:0",
          desc: "Placeholder 32-bit field for extracted signal"
        }
      ]
    },
    {
      name: "can_top_level_int_ena",
      desc: "Auto-extracted signal int_ena from can_top_level.vhd",
      swaccess: "rw",
      hwaccess: "hrw",
      fields: [
        {
          name: "value",
          bits: "31:0",
          desc: "Placeholder 32-bit field for extracted signal"
        }
      ]
    },
    {
      name: "can_top_level_int_mask",
      desc: "Auto-extracted signal int_mask from can_top_level.vhd",
      swaccess: "rw",
      hwaccess: "hrw",
      fields: [
        {
          name: "value",
          bits: "31:0",
          desc: "Placeholder 32-bit field for extracted signal"
        }
      ]
    },
    {
      name: "can_top_level_rec_ident",
      desc: "Auto-extracted signal rec_ident from can_top_level.vhd",
      swaccess: "rw",
      hwaccess: "hrw",
      fields: [
        {
          name: "value",
          bits: "31:0",
          desc: "Placeholder 32-bit field for extracted signal"
        }
      ]
    },
    {
      name: "can_top_level_rec_dlc",
      desc: "Auto-extracted signal rec_dlc from can_top_level.vhd",
      swaccess: "rw",
      hwaccess: "hrw",
      fields: [
        {
          name: "value",
          bits: "31:0",
          desc: "Placeholder 32-bit field for extracted signal"
        }
      ]
    },
    {
      name: "can_top_level_rec_ident_type",
      desc: "Auto-extracted signal rec_ident_type from can_top_level.vhd",
      swaccess: "rw",
      hwaccess: "hrw",
      fields: [
        {
          name: "value",
          bits: "31:0",
          desc: "Placeholder 32-bit field for extracted signal"
        }
      ]
    },
    {
      name: "can_top_level_rec_frame_type",
      desc: "Auto-extracted signal rec_frame_type from can_top_level.vhd",
      swaccess: "rw",
      hwaccess: "hrw",
      fields: [
        {
          name: "value",
          bits: "31:0",
          desc: "Placeholder 32-bit field for extracted signal"
        }
      ]
    },
    {
      name: "can_top_level_rec_is_rtr",
      desc: "Auto-extracted signal rec_is_rtr from can_top_level.vhd",
      swaccess: "rw",
      hwaccess: "hrw",
      fields: [
        {
          name: "value",
          bits: "31:0",
          desc: "Placeholder 32-bit field for extracted signal"
        }
      ]
    },
    {
      name: "can_top_level_rec_brs",
      desc: "Auto-extracted signal rec_brs from can_top_level.vhd",
      swaccess: "rw",
      hwaccess: "hrw",
      fields: [
        {
          name: "value",
          bits: "31:0",
          desc: "Placeholder 32-bit field for extracted signal"
        }
      ]
    },
    {
      name: "can_top_level_rec_esi",
      desc: "Auto-extracted signal rec_esi from can_top_level.vhd",
      swaccess: "rw",
      hwaccess: "hrw",
      fields: [
        {
          name: "value",
          bits: "31:0",
          desc: "Placeholder 32-bit field for extracted signal"
        }
      ]
    },
    {
      name: "can_top_level_store_data_word",
      desc: "Auto-extracted signal store_data_word from can_top_level.vhd",
      swaccess: "rw",
      hwaccess: "hrw",
      fields: [
        {
          name: "value",
          bits: "31:0",
          desc: "Placeholder 32-bit field for extracted signal"
        }
      ]
    },
    {
      name: "can_top_level_sof_pulse",
      desc: "Auto-extracted signal sof_pulse from can_top_level.vhd",
      swaccess: "rw",
      hwaccess: "hrw",
      fields: [
        {
          name: "value",
          bits: "31:0",
          desc: "Placeholder 32-bit field for extracted signal"
        }
      ]
    },
    {
      name: "can_top_level_store_metadata",
      desc: "Auto-extracted signal store_metadata from can_top_level.vhd",
      swaccess: "rw",
      hwaccess: "hrw",
      fields: [
        {
          name: "value",
          bits: "31:0",
          desc: "Placeholder 32-bit field for extracted signal"
        }
      ]
    },
    {
      name: "can_top_level_store_data",
      desc: "Auto-extracted signal store_data from can_top_level.vhd",
      swaccess: "rw",
      hwaccess: "hrw",
      fields: [
        {
          name: "value",
          bits: "31:0",
          desc: "Placeholder 32-bit field for extracted signal"
        }
      ]
    },
    {
      name: "can_top_level_rec_valid",
      desc: "Auto-extracted signal rec_valid from can_top_level.vhd",
      swaccess: "rw",
      hwaccess: "hrw",
      fields: [
        {
          name: "value",
          bits: "31:0",
          desc: "Placeholder 32-bit field for extracted signal"
        }
      ]
    },
    {
      name: "can_top_level_rec_abort",
      desc: "Auto-extracted signal rec_abort from can_top_level.vhd",
      swaccess: "rw",
      hwaccess: "hrw",
      fields: [
        {
          name: "value",
          bits: "31:0",
          desc: "Placeholder 32-bit field for extracted signal"
        }
      ]
    },
    {
      name: "can_top_level_store_metadata_f",
      desc: "Auto-extracted signal store_metadata_f from can_top_level.vhd",
      swaccess: "rw",
      hwaccess: "hrw",
      fields: [
        {
          name: "value",
          bits: "31:0",
          desc: "Placeholder 32-bit field for extracted signal"
        }
      ]
    },
    {
      name: "can_top_level_store_data_f",
      desc: "Auto-extracted signal store_data_f from can_top_level.vhd",
      swaccess: "rw",
      hwaccess: "hrw",
      fields: [
        {
          name: "value",
          bits: "31:0",
          desc: "Placeholder 32-bit field for extracted signal"
        }
      ]
    },
    {
      name: "can_top_level_rec_valid_f",
      desc: "Auto-extracted signal rec_valid_f from can_top_level.vhd",
      swaccess: "rw",
      hwaccess: "hrw",
      fields: [
        {
          name: "value",
          bits: "31:0",
          desc: "Placeholder 32-bit field for extracted signal"
        }
      ]
    },
    {
      name: "can_top_level_rec_abort_f",
      desc: "Auto-extracted signal rec_abort_f from can_top_level.vhd",
      swaccess: "rw",
      hwaccess: "hrw",
      fields: [
        {
          name: "value",
          bits: "31:0",
          desc: "Placeholder 32-bit field for extracted signal"
        }
      ]
    },
    {
      name: "can_top_level_txtb_hw_cmd_int",
      desc: "Auto-extracted signal txtb_hw_cmd_int from can_top_level.vhd",
      swaccess: "rw",
      hwaccess: "hrw",
      fields: [
        {
          name: "value",
          bits: "31:0",
          desc: "Placeholder 32-bit field for extracted signal"
        }
      ]
    },
    {
      name: "can_top_level_is_bus_off",
      desc: "Auto-extracted signal is_bus_off from can_top_level.vhd",
      swaccess: "rw",
      hwaccess: "hrw",
      fields: [
        {
          name: "value",
          bits: "31:0",
          desc: "Placeholder 32-bit field for extracted signal"
        }
      ]
    },
    {
      name: "can_top_level_txtb_available",
      desc: "Auto-extracted signal txtb_available from can_top_level.vhd",
      swaccess: "rw",
      hwaccess: "hrw",
      fields: [
        {
          name: "value",
          bits: "31:0",
          desc: "Placeholder 32-bit field for extracted signal"
        }
      ]
    },
    {
      name: "can_top_level_txtb_port_b_clk_en",
      desc: "Auto-extracted signal txtb_port_b_clk_en from can_top_level.vhd",
      swaccess: "rw",
      hwaccess: "hrw",
      fields: [
        {
          name: "value",
          bits: "31:0",
          desc: "Placeholder 32-bit field for extracted signal"
        }
      ]
    },
    {
      name: "can_top_level_tran_dlc",
      desc: "Auto-extracted signal tran_dlc from can_top_level.vhd",
      swaccess: "rw",
      hwaccess: "hrw",
      fields: [
        {
          name: "value",
          bits: "31:0",
          desc: "Placeholder 32-bit field for extracted signal"
        }
      ]
    },
    {
      name: "can_top_level_tran_is_rtr",
      desc: "Auto-extracted signal tran_is_rtr from can_top_level.vhd",
      swaccess: "rw",
      hwaccess: "hrw",
      fields: [
        {
          name: "value",
          bits: "31:0",
          desc: "Placeholder 32-bit field for extracted signal"
        }
      ]
    },
    {
      name: "can_top_level_tran_ident_type",
      desc: "Auto-extracted signal tran_ident_type from can_top_level.vhd",
      swaccess: "rw",
      hwaccess: "hrw",
      fields: [
        {
          name: "value",
          bits: "31:0",
          desc: "Placeholder 32-bit field for extracted signal"
        }
      ]
    },
    {
      name: "can_top_level_tran_frame_type",
      desc: "Auto-extracted signal tran_frame_type from can_top_level.vhd",
      swaccess: "rw",
      hwaccess: "hrw",
      fields: [
        {
          name: "value",
          bits: "31:0",
          desc: "Placeholder 32-bit field for extracted signal"
        }
      ]
    },
    {
      name: "can_top_level_tran_brs",
      desc: "Auto-extracted signal tran_brs from can_top_level.vhd",
      swaccess: "rw",
      hwaccess: "hrw",
      fields: [
        {
          name: "value",
          bits: "31:0",
          desc: "Placeholder 32-bit field for extracted signal"
        }
      ]
    },
    {
      name: "can_top_level_tran_identifier",
      desc: "Auto-extracted signal tran_identifier from can_top_level.vhd",
      swaccess: "rw",
      hwaccess: "hrw",
      fields: [
        {
          name: "value",
          bits: "31:0",
          desc: "Placeholder 32-bit field for extracted signal"
        }
      ]
    },
    {
      name: "can_top_level_tran_word",
      desc: "Auto-extracted signal tran_word from can_top_level.vhd",
      swaccess: "rw",
      hwaccess: "hrw",
      fields: [
        {
          name: "value",
          bits: "31:0",
          desc: "Placeholder 32-bit field for extracted signal"
        }
      ]
    },
    {
      name: "can_top_level_tran_frame_valid",
      desc: "Auto-extracted signal tran_frame_valid from can_top_level.vhd",
      swaccess: "rw",
      hwaccess: "hrw",
      fields: [
        {
          name: "value",
          bits: "31:0",
          desc: "Placeholder 32-bit field for extracted signal"
        }
      ]
    },
    {
      name: "can_top_level_txtb_changed",
      desc: "Auto-extracted signal txtb_changed from can_top_level.vhd",
      swaccess: "rw",
      hwaccess: "hrw",
      fields: [
        {
          name: "value",
          bits: "31:0",
          desc: "Placeholder 32-bit field for extracted signal"
        }
      ]
    },
    {
      name: "can_top_level_txtb_clk_en",
      desc: "Auto-extracted signal txtb_clk_en from can_top_level.vhd",
      swaccess: "rw",
      hwaccess: "hrw",
      fields: [
        {
          name: "value",
          bits: "31:0",
          desc: "Placeholder 32-bit field for extracted signal"
        }
      ]
    },
    {
      name: "can_top_level_err_detected",
      desc: "Auto-extracted signal err_detected from can_top_level.vhd",
      swaccess: "rw",
      hwaccess: "hrw",
      fields: [
        {
          name: "value",
          bits: "31:0",
          desc: "Placeholder 32-bit field for extracted signal"
        }
      ]
    },
    {
      name: "can_top_level_fcs_changed",
      desc: "Auto-extracted signal fcs_changed from can_top_level.vhd",
      swaccess: "rw",
      hwaccess: "hrw",
      fields: [
        {
          name: "value",
          bits: "31:0",
          desc: "Placeholder 32-bit field for extracted signal"
        }
      ]
    },
    {
      name: "can_top_level_err_warning_limit",
      desc: "Auto-extracted signal err_warning_limit from can_top_level.vhd",
      swaccess: "rw",
      hwaccess: "hrw",
      fields: [
        {
          name: "value",
          bits: "31:0",
          desc: "Placeholder 32-bit field for extracted signal"
        }
      ]
    },
    {
      name: "can_top_level_arbitration_lost",
      desc: "Auto-extracted signal arbitration_lost from can_top_level.vhd",
      swaccess: "rw",
      hwaccess: "hrw",
      fields: [
        {
          name: "value",
          bits: "31:0",
          desc: "Placeholder 32-bit field for extracted signal"
        }
      ]
    },
    {
      name: "can_top_level_tran_valid",
      desc: "Auto-extracted signal tran_valid from can_top_level.vhd",
      swaccess: "rw",
      hwaccess: "hrw",
      fields: [
        {
          name: "value",
          bits: "31:0",
          desc: "Placeholder 32-bit field for extracted signal"
        }
      ]
    },
    {
      name: "can_top_level_br_shifted",
      desc: "Auto-extracted signal br_shifted from can_top_level.vhd",
      swaccess: "rw",
      hwaccess: "hrw",
      fields: [
        {
          name: "value",
          bits: "31:0",
          desc: "Placeholder 32-bit field for extracted signal"
        }
      ]
    },
    {
      name: "can_top_level_is_overload",
      desc: "Auto-extracted signal is_overload from can_top_level.vhd",
      swaccess: "rw",
      hwaccess: "hrw",
      fields: [
        {
          name: "value",
          bits: "31:0",
          desc: "Placeholder 32-bit field for extracted signal"
        }
      ]
    },
    {
      name: "can_top_level_rx_triggers",
      desc: "Auto-extracted signal rx_triggers from can_top_level.vhd",
      swaccess: "rw",
      hwaccess: "hrw",
      fields: [
        {
          name: "value",
          bits: "31:0",
          desc: "Placeholder 32-bit field for extracted signal"
        }
      ]
    },
    {
      name: "can_top_level_tx_trigger",
      desc: "Auto-extracted signal tx_trigger from can_top_level.vhd",
      swaccess: "rw",
      hwaccess: "hrw",
      fields: [
        {
          name: "value",
          bits: "31:0",
          desc: "Placeholder 32-bit field for extracted signal"
        }
      ]
    },
    {
      name: "can_top_level_sync_control",
      desc: "Auto-extracted signal sync_control from can_top_level.vhd",
      swaccess: "rw",
      hwaccess: "hrw",
      fields: [
        {
          name: "value",
          bits: "31:0",
          desc: "Placeholder 32-bit field for extracted signal"
        }
      ]
    },
    {
      name: "can_top_level_no_pos_resync",
      desc: "Auto-extracted signal no_pos_resync from can_top_level.vhd",
      swaccess: "rw",
      hwaccess: "hrw",
      fields: [
        {
          name: "value",
          bits: "31:0",
          desc: "Placeholder 32-bit field for extracted signal"
        }
      ]
    },
    {
      name: "can_top_level_nbt_ctrs_en",
      desc: "Auto-extracted signal nbt_ctrs_en from can_top_level.vhd",
      swaccess: "rw",
      hwaccess: "hrw",
      fields: [
        {
          name: "value",
          bits: "31:0",
          desc: "Placeholder 32-bit field for extracted signal"
        }
      ]
    },
    {
      name: "can_top_level_dbt_ctrs_en",
      desc: "Auto-extracted signal dbt_ctrs_en from can_top_level.vhd",
      swaccess: "rw",
      hwaccess: "hrw",
      fields: [
        {
          name: "value",
          bits: "31:0",
          desc: "Placeholder 32-bit field for extracted signal"
        }
      ]
    },
    {
      name: "can_top_level_trv_delay",
      desc: "Auto-extracted signal trv_delay from can_top_level.vhd",
      swaccess: "rw",
      hwaccess: "hrw",
      fields: [
        {
          name: "value",
          bits: "31:0",
          desc: "Placeholder 32-bit field for extracted signal"
        }
      ]
    },
    {
      name: "can_top_level_rx_data_wbs",
      desc: "Auto-extracted signal rx_data_wbs from can_top_level.vhd",
      swaccess: "rw",
      hwaccess: "hrw",
      fields: [
        {
          name: "value",
          bits: "31:0",
          desc: "Placeholder 32-bit field for extracted signal"
        }
      ]
    },
    {
      name: "can_top_level_tx_data_wbs",
      desc: "Auto-extracted signal tx_data_wbs from can_top_level.vhd",
      swaccess: "rw",
      hwaccess: "hrw",
      fields: [
        {
          name: "value",
          bits: "31:0",
          desc: "Placeholder 32-bit field for extracted signal"
        }
      ]
    },
    {
      name: "can_top_level_ssp_reset",
      desc: "Auto-extracted signal ssp_reset from can_top_level.vhd",
      swaccess: "rw",
      hwaccess: "hrw",
      fields: [
        {
          name: "value",
          bits: "31:0",
          desc: "Placeholder 32-bit field for extracted signal"
        }
      ]
    },
    {
      name: "can_top_level_tran_delay_meas",
      desc: "Auto-extracted signal tran_delay_meas from can_top_level.vhd",
      swaccess: "rw",
      hwaccess: "hrw",
      fields: [
        {
          name: "value",
          bits: "31:0",
          desc: "Placeholder 32-bit field for extracted signal"
        }
      ]
    },
    {
      name: "can_top_level_bit_err",
      desc: "Auto-extracted signal bit_err from can_top_level.vhd",
      swaccess: "rw",
      hwaccess: "hrw",
      fields: [
        {
          name: "value",
          bits: "31:0",
          desc: "Placeholder 32-bit field for extracted signal"
        }
      ]
    },
    {
      name: "can_top_level_sample_sec",
      desc: "Auto-extracted signal sample_sec from can_top_level.vhd",
      swaccess: "rw",
      hwaccess: "hrw",
      fields: [
        {
          name: "value",
          bits: "31:0",
          desc: "Placeholder 32-bit field for extracted signal"
        }
      ]
    },
    {
      name: "can_top_level_btmc_reset",
      desc: "Auto-extracted signal btmc_reset from can_top_level.vhd",
      swaccess: "rw",
      hwaccess: "hrw",
      fields: [
        {
          name: "value",
          bits: "31:0",
          desc: "Placeholder 32-bit field for extracted signal"
        }
      ]
    },
    {
      name: "can_top_level_dbt_measure_start",
      desc: "Auto-extracted signal dbt_measure_start from can_top_level.vhd",
      swaccess: "rw",
      hwaccess: "hrw",
      fields: [
        {
          name: "value",
          bits: "31:0",
          desc: "Placeholder 32-bit field for extracted signal"
        }
      ]
    },
    {
      name: "can_top_level_gen_first_ssp",
      desc: "Auto-extracted signal gen_first_ssp from can_top_level.vhd",
      swaccess: "rw",
      hwaccess: "hrw",
      fields: [
        {
          name: "value",
          bits: "31:0",
          desc: "Placeholder 32-bit field for extracted signal"
        }
      ]
    },
    {
      name: "can_top_level_sync_edge",
      desc: "Auto-extracted signal sync_edge from can_top_level.vhd",
      swaccess: "rw",
      hwaccess: "hrw",
      fields: [
        {
          name: "value",
          bits: "31:0",
          desc: "Placeholder 32-bit field for extracted signal"
        }
      ]
    },
    {
      name: "can_top_level_tq_edge",
      desc: "Auto-extracted signal tq_edge from can_top_level.vhd",
      swaccess: "rw",
      hwaccess: "hrw",
      fields: [
        {
          name: "value",
          bits: "31:0",
          desc: "Placeholder 32-bit field for extracted signal"
        }
      ]
    },
    {
      name: "can_top_level_tst_rdata_rx_buf",
      desc: "Auto-extracted signal tst_rdata_rx_buf from can_top_level.vhd",
      swaccess: "rw",
      hwaccess: "hrw",
      fields: [
        {
          name: "value",
          bits: "31:0",
          desc: "Placeholder 32-bit field for extracted signal"
        }
      ]
    },
    {
      name: "clk_gate_clk_en_q",
      desc: "Auto-extracted signal clk_en_q from clk_gate.vhd",
      swaccess: "rw",
      hwaccess: "hrw",
      fields: [
        {
          name: "value",
          bits: "31:0",
          desc: "Placeholder 32-bit field for extracted signal"
        }
      ]
    },
    {
      name: "control_counter_ctrl_ctr_ce",
      desc: "Auto-extracted signal ctrl_ctr_ce from control_counter.vhd",
      swaccess: "rw",
      hwaccess: "hrw",
      fields: [
        {
          name: "value",
          bits: "31:0",
          desc: "Placeholder 32-bit field for extracted signal"
        }
      ]
    },
    {
      name: "control_counter_compl_ctr_ce",
      desc: "Auto-extracted signal compl_ctr_ce from control_counter.vhd",
      swaccess: "rw",
      hwaccess: "hrw",
      fields: [
        {
          name: "value",
          bits: "31:0",
          desc: "Placeholder 32-bit field for extracted signal"
        }
      ]
    },
    {
      name: "control_registers_reg_map_reg_sel",
      desc: "Auto-extracted signal reg_sel from control_registers_reg_map.vhd",
      swaccess: "rw",
      hwaccess: "hrw",
      fields: [
        {
          name: "value",
          bits: "31:0",
          desc: "Placeholder 32-bit field for extracted signal"
        }
      ]
    },
    {
      name: "control_registers_reg_map_read_data_mux_in",
      desc: "Auto-extracted signal read_data_mux_in from control_registers_reg_map.vhd",
      swaccess: "rw",
      hwaccess: "hrw",
      fields: [
        {
          name: "value",
          bits: "31:0",
          desc: "Placeholder 32-bit field for extracted signal"
        }
      ]
    },
    {
      name: "control_registers_reg_map_read_data_mask_n",
      desc: "Auto-extracted signal read_data_mask_n from control_registers_reg_map.vhd",
      swaccess: "rw",
      hwaccess: "hrw",
      fields: [
        {
          name: "value",
          bits: "31:0",
          desc: "Placeholder 32-bit field for extracted signal"
        }
      ]
    },
    {
      name: "control_registers_reg_map_read_mux_ena",
      desc: "Auto-extracted signal read_mux_ena from control_registers_reg_map.vhd",
      swaccess: "rw",
      hwaccess: "hrw",
      fields: [
        {
          name: "value",
          bits: "31:0",
          desc: "Placeholder 32-bit field for extracted signal"
        }
      ]
    },
    {
      name: "crc_calc_crc_q",
      desc: "Auto-extracted signal crc_q from crc_calc.vhd",
      swaccess: "rw",
      hwaccess: "hrw",
      fields: [
        {
          name: "value",
          bits: "31:0",
          desc: "Placeholder 32-bit field for extracted signal"
        }
      ]
    },
    {
      name: "crc_calc_crc_nxt",
      desc: "Auto-extracted signal crc_nxt from crc_calc.vhd",
      swaccess: "rw",
      hwaccess: "hrw",
      fields: [
        {
          name: "value",
          bits: "31:0",
          desc: "Placeholder 32-bit field for extracted signal"
        }
      ]
    },
    {
      name: "crc_calc_crc_shift",
      desc: "Auto-extracted signal crc_shift from crc_calc.vhd",
      swaccess: "rw",
      hwaccess: "hrw",
      fields: [
        {
          name: "value",
          bits: "31:0",
          desc: "Placeholder 32-bit field for extracted signal"
        }
      ]
    },
    {
      name: "crc_calc_crc_shift_n_xor",
      desc: "Auto-extracted signal crc_shift_n_xor from crc_calc.vhd",
      swaccess: "rw",
      hwaccess: "hrw",
      fields: [
        {
          name: "value",
          bits: "31:0",
          desc: "Placeholder 32-bit field for extracted signal"
        }
      ]
    },
    {
      name: "crc_calc_crc_d",
      desc: "Auto-extracted signal crc_d from crc_calc.vhd",
      swaccess: "rw",
      hwaccess: "hrw",
      fields: [
        {
          name: "value",
          bits: "31:0",
          desc: "Placeholder 32-bit field for extracted signal"
        }
      ]
    },
    {
      name: "crc_calc_crc_ce",
      desc: "Auto-extracted signal crc_ce from crc_calc.vhd",
      swaccess: "rw",
      hwaccess: "hrw",
      fields: [
        {
          name: "value",
          bits: "31:0",
          desc: "Placeholder 32-bit field for extracted signal"
        }
      ]
    },
    {
      name: "data_edge_detector_rx_data_prev",
      desc: "Auto-extracted signal rx_data_prev from data_edge_detector.vhd",
      swaccess: "rw",
      hwaccess: "hrw",
      fields: [
        {
          name: "value",
          bits: "31:0",
          desc: "Placeholder 32-bit field for extracted signal"
        }
      ]
    },
    {
      name: "data_edge_detector_tx_data_prev",
      desc: "Auto-extracted signal tx_data_prev from data_edge_detector.vhd",
      swaccess: "rw",
      hwaccess: "hrw",
      fields: [
        {
          name: "value",
          bits: "31:0",
          desc: "Placeholder 32-bit field for extracted signal"
        }
      ]
    },
    {
      name: "data_edge_detector_rx_data_sync_prev",
      desc: "Auto-extracted signal rx_data_sync_prev from data_edge_detector.vhd",
      swaccess: "rw",
      hwaccess: "hrw",
      fields: [
        {
          name: "value",
          bits: "31:0",
          desc: "Placeholder 32-bit field for extracted signal"
        }
      ]
    },
    {
      name: "data_edge_detector_rx_edge_i",
      desc: "Auto-extracted signal rx_edge_i from data_edge_detector.vhd",
      swaccess: "rw",
      hwaccess: "hrw",
      fields: [
        {
          name: "value",
          bits: "31:0",
          desc: "Placeholder 32-bit field for extracted signal"
        }
      ]
    },
    {
      name: "data_edge_detector_tx_edge_i",
      desc: "Auto-extracted signal tx_edge_i from data_edge_detector.vhd",
      swaccess: "rw",
      hwaccess: "hrw",
      fields: [
        {
          name: "value",
          bits: "31:0",
          desc: "Placeholder 32-bit field for extracted signal"
        }
      ]
    },
    {
      name: "data_mux_sel_data",
      desc: "Auto-extracted signal sel_data from data_mux.vhd",
      swaccess: "rw",
      hwaccess: "hrw",
      fields: [
        {
          name: "value",
          bits: "31:0",
          desc: "Placeholder 32-bit field for extracted signal"
        }
      ]
    },
    {
      name: "data_mux_saturated_data",
      desc: "Auto-extracted signal saturated_data from data_mux.vhd",
      swaccess: "rw",
      hwaccess: "hrw",
      fields: [
        {
          name: "value",
          bits: "31:0",
          desc: "Placeholder 32-bit field for extracted signal"
        }
      ]
    },
    {
      name: "data_mux_masked_data",
      desc: "Auto-extracted signal masked_data from data_mux.vhd",
      swaccess: "rw",
      hwaccess: "hrw",
      fields: [
        {
          name: "value",
          bits: "31:0",
          desc: "Placeholder 32-bit field for extracted signal"
        }
      ]
    },
    {
      name: "dlc_decoder_data_len_8_to_64",
      desc: "Auto-extracted signal data_len_8_to_64 from dlc_decoder.vhd",
      swaccess: "rw",
      hwaccess: "hrw",
      fields: [
        {
          name: "value",
          bits: "31:0",
          desc: "Placeholder 32-bit field for extracted signal"
        }
      ]
    },
    {
      name: "dlc_decoder_data_len_can_2_0",
      desc: "Auto-extracted signal data_len_can_2_0 from dlc_decoder.vhd",
      swaccess: "rw",
      hwaccess: "hrw",
      fields: [
        {
          name: "value",
          bits: "31:0",
          desc: "Placeholder 32-bit field for extracted signal"
        }
      ]
    },
    {
      name: "dlc_decoder_data_len_can_fd",
      desc: "Auto-extracted signal data_len_can_fd from dlc_decoder.vhd",
      swaccess: "rw",
      hwaccess: "hrw",
      fields: [
        {
          name: "value",
          bits: "31:0",
          desc: "Placeholder 32-bit field for extracted signal"
        }
      ]
    },
    {
      name: "endian_swapper_swapped",
      desc: "Auto-extracted signal swapped from endian_swapper.vhd",
      swaccess: "rw",
      hwaccess: "hrw",
      fields: [
        {
          name: "value",
          bits: "31:0",
          desc: "Placeholder 32-bit field for extracted signal"
        }
      ]
    },
    {
      name: "err_counters_tx_err_ctr_ce",
      desc: "Auto-extracted signal tx_err_ctr_ce from err_counters.vhd",
      swaccess: "rw",
      hwaccess: "hrw",
      fields: [
        {
          name: "value",
          bits: "31:0",
          desc: "Placeholder 32-bit field for extracted signal"
        }
      ]
    },
    {
      name: "err_counters_rx_err_ctr_ce",
      desc: "Auto-extracted signal rx_err_ctr_ce from err_counters.vhd",
      swaccess: "rw",
      hwaccess: "hrw",
      fields: [
        {
          name: "value",
          bits: "31:0",
          desc: "Placeholder 32-bit field for extracted signal"
        }
      ]
    },
    {
      name: "err_counters_modif_tx_ctr",
      desc: "Auto-extracted signal modif_tx_ctr from err_counters.vhd",
      swaccess: "rw",
      hwaccess: "hrw",
      fields: [
        {
          name: "value",
          bits: "31:0",
          desc: "Placeholder 32-bit field for extracted signal"
        }
      ]
    },
    {
      name: "err_counters_modif_rx_ctr",
      desc: "Auto-extracted signal modif_rx_ctr from err_counters.vhd",
      swaccess: "rw",
      hwaccess: "hrw",
      fields: [
        {
          name: "value",
          bits: "31:0",
          desc: "Placeholder 32-bit field for extracted signal"
        }
      ]
    },
    {
      name: "err_counters_nom_err_ctr_ce",
      desc: "Auto-extracted signal nom_err_ctr_ce from err_counters.vhd",
      swaccess: "rw",
      hwaccess: "hrw",
      fields: [
        {
          name: "value",
          bits: "31:0",
          desc: "Placeholder 32-bit field for extracted signal"
        }
      ]
    },
    {
      name: "err_counters_data_err_ctr_ce",
      desc: "Auto-extracted signal data_err_ctr_ce from err_counters.vhd",
      swaccess: "rw",
      hwaccess: "hrw",
      fields: [
        {
          name: "value",
          bits: "31:0",
          desc: "Placeholder 32-bit field for extracted signal"
        }
      ]
    },
    {
      name: "err_counters_res_err_ctrs_d",
      desc: "Auto-extracted signal res_err_ctrs_d from err_counters.vhd",
      swaccess: "rw",
      hwaccess: "hrw",
      fields: [
        {
          name: "value",
          bits: "31:0",
          desc: "Placeholder 32-bit field for extracted signal"
        }
      ]
    },
    {
      name: "err_counters_res_err_ctrs_q",
      desc: "Auto-extracted signal res_err_ctrs_q from err_counters.vhd",
      swaccess: "rw",
      hwaccess: "hrw",
      fields: [
        {
          name: "value",
          bits: "31:0",
          desc: "Placeholder 32-bit field for extracted signal"
        }
      ]
    },
    {
      name: "err_counters_res_err_ctrs_q_scan",
      desc: "Auto-extracted signal res_err_ctrs_q_scan from err_counters.vhd",
      swaccess: "rw",
      hwaccess: "hrw",
      fields: [
        {
          name: "value",
          bits: "31:0",
          desc: "Placeholder 32-bit field for extracted signal"
        }
      ]
    },
    {
      name: "err_detector_err_frm_req_i",
      desc: "Auto-extracted signal err_frm_req_i from err_detector.vhd",
      swaccess: "rw",
      hwaccess: "hrw",
      fields: [
        {
          name: "value",
          bits: "31:0",
          desc: "Placeholder 32-bit field for extracted signal"
        }
      ]
    },
    {
      name: "err_detector_err_type_d",
      desc: "Auto-extracted signal err_type_d from err_detector.vhd",
      swaccess: "rw",
      hwaccess: "hrw",
      fields: [
        {
          name: "value",
          bits: "31:0",
          desc: "Placeholder 32-bit field for extracted signal"
        }
      ]
    },
    {
      name: "err_detector_err_type_q",
      desc: "Auto-extracted signal err_type_q from err_detector.vhd",
      swaccess: "rw",
      hwaccess: "hrw",
      fields: [
        {
          name: "value",
          bits: "31:0",
          desc: "Placeholder 32-bit field for extracted signal"
        }
      ]
    },
    {
      name: "err_detector_err_pos_q",
      desc: "Auto-extracted signal err_pos_q from err_detector.vhd",
      swaccess: "rw",
      hwaccess: "hrw",
      fields: [
        {
          name: "value",
          bits: "31:0",
          desc: "Placeholder 32-bit field for extracted signal"
        }
      ]
    },
    {
      name: "err_detector_form_err_i",
      desc: "Auto-extracted signal form_err_i from err_detector.vhd",
      swaccess: "rw",
      hwaccess: "hrw",
      fields: [
        {
          name: "value",
          bits: "31:0",
          desc: "Placeholder 32-bit field for extracted signal"
        }
      ]
    },
    {
      name: "err_detector_crc_match_c",
      desc: "Auto-extracted signal crc_match_c from err_detector.vhd",
      swaccess: "rw",
      hwaccess: "hrw",
      fields: [
        {
          name: "value",
          bits: "31:0",
          desc: "Placeholder 32-bit field for extracted signal"
        }
      ]
    },
    {
      name: "err_detector_crc_match_d",
      desc: "Auto-extracted signal crc_match_d from err_detector.vhd",
      swaccess: "rw",
      hwaccess: "hrw",
      fields: [
        {
          name: "value",
          bits: "31:0",
          desc: "Placeholder 32-bit field for extracted signal"
        }
      ]
    },
    {
      name: "err_detector_crc_match_q",
      desc: "Auto-extracted signal crc_match_q from err_detector.vhd",
      swaccess: "rw",
      hwaccess: "hrw",
      fields: [
        {
          name: "value",
          bits: "31:0",
          desc: "Placeholder 32-bit field for extracted signal"
        }
      ]
    },
    {
      name: "err_detector_dst_ctr_grey",
      desc: "Auto-extracted signal dst_ctr_grey from err_detector.vhd",
      swaccess: "rw",
      hwaccess: "hrw",
      fields: [
        {
          name: "value",
          bits: "31:0",
          desc: "Placeholder 32-bit field for extracted signal"
        }
      ]
    },
    {
      name: "err_detector_dst_parity",
      desc: "Auto-extracted signal dst_parity from err_detector.vhd",
      swaccess: "rw",
      hwaccess: "hrw",
      fields: [
        {
          name: "value",
          bits: "31:0",
          desc: "Placeholder 32-bit field for extracted signal"
        }
      ]
    },
    {
      name: "err_detector_stuff_count_check",
      desc: "Auto-extracted signal stuff_count_check from err_detector.vhd",
      swaccess: "rw",
      hwaccess: "hrw",
      fields: [
        {
          name: "value",
          bits: "31:0",
          desc: "Placeholder 32-bit field for extracted signal"
        }
      ]
    },
    {
      name: "err_detector_crc_15_ok",
      desc: "Auto-extracted signal crc_15_ok from err_detector.vhd",
      swaccess: "rw",
      hwaccess: "hrw",
      fields: [
        {
          name: "value",
          bits: "31:0",
          desc: "Placeholder 32-bit field for extracted signal"
        }
      ]
    },
    {
      name: "err_detector_crc_17_ok",
      desc: "Auto-extracted signal crc_17_ok from err_detector.vhd",
      swaccess: "rw",
      hwaccess: "hrw",
      fields: [
        {
          name: "value",
          bits: "31:0",
          desc: "Placeholder 32-bit field for extracted signal"
        }
      ]
    },
    {
      name: "err_detector_crc_21_ok",
      desc: "Auto-extracted signal crc_21_ok from err_detector.vhd",
      swaccess: "rw",
      hwaccess: "hrw",
      fields: [
        {
          name: "value",
          bits: "31:0",
          desc: "Placeholder 32-bit field for extracted signal"
        }
      ]
    },
    {
      name: "err_detector_stuff_count_ok",
      desc: "Auto-extracted signal stuff_count_ok from err_detector.vhd",
      swaccess: "rw",
      hwaccess: "hrw",
      fields: [
        {
          name: "value",
          bits: "31:0",
          desc: "Placeholder 32-bit field for extracted signal"
        }
      ]
    },
    {
      name: "err_detector_rx_crc_15",
      desc: "Auto-extracted signal rx_crc_15 from err_detector.vhd",
      swaccess: "rw",
      hwaccess: "hrw",
      fields: [
        {
          name: "value",
          bits: "31:0",
          desc: "Placeholder 32-bit field for extracted signal"
        }
      ]
    },
    {
      name: "err_detector_rx_crc_17",
      desc: "Auto-extracted signal rx_crc_17 from err_detector.vhd",
      swaccess: "rw",
      hwaccess: "hrw",
      fields: [
        {
          name: "value",
          bits: "31:0",
          desc: "Placeholder 32-bit field for extracted signal"
        }
      ]
    },
    {
      name: "err_detector_rx_crc_21",
      desc: "Auto-extracted signal rx_crc_21 from err_detector.vhd",
      swaccess: "rw",
      hwaccess: "hrw",
      fields: [
        {
          name: "value",
          bits: "31:0",
          desc: "Placeholder 32-bit field for extracted signal"
        }
      ]
    },
    {
      name: "fault_confinement_drv_ewl",
      desc: "Auto-extracted signal drv_ewl from fault_confinement.vhd",
      swaccess: "rw",
      hwaccess: "hrw",
      fields: [
        {
          name: "value",
          bits: "31:0",
          desc: "Placeholder 32-bit field for extracted signal"
        }
      ]
    },
    {
      name: "fault_confinement_drv_erp",
      desc: "Auto-extracted signal drv_erp from fault_confinement.vhd",
      swaccess: "rw",
      hwaccess: "hrw",
      fields: [
        {
          name: "value",
          bits: "31:0",
          desc: "Placeholder 32-bit field for extracted signal"
        }
      ]
    },
    {
      name: "fault_confinement_drv_ctr_val",
      desc: "Auto-extracted signal drv_ctr_val from fault_confinement.vhd",
      swaccess: "rw",
      hwaccess: "hrw",
      fields: [
        {
          name: "value",
          bits: "31:0",
          desc: "Placeholder 32-bit field for extracted signal"
        }
      ]
    },
    {
      name: "fault_confinement_drv_ctr_sel",
      desc: "Auto-extracted signal drv_ctr_sel from fault_confinement.vhd",
      swaccess: "rw",
      hwaccess: "hrw",
      fields: [
        {
          name: "value",
          bits: "31:0",
          desc: "Placeholder 32-bit field for extracted signal"
        }
      ]
    },
    {
      name: "fault_confinement_drv_ena",
      desc: "Auto-extracted signal drv_ena from fault_confinement.vhd",
      swaccess: "rw",
      hwaccess: "hrw",
      fields: [
        {
          name: "value",
          bits: "31:0",
          desc: "Placeholder 32-bit field for extracted signal"
        }
      ]
    },
    {
      name: "fault_confinement_tx_err_ctr_i",
      desc: "Auto-extracted signal tx_err_ctr_i from fault_confinement.vhd",
      swaccess: "rw",
      hwaccess: "hrw",
      fields: [
        {
          name: "value",
          bits: "31:0",
          desc: "Placeholder 32-bit field for extracted signal"
        }
      ]
    },
    {
      name: "fault_confinement_rx_err_ctr_i",
      desc: "Auto-extracted signal rx_err_ctr_i from fault_confinement.vhd",
      swaccess: "rw",
      hwaccess: "hrw",
      fields: [
        {
          name: "value",
          bits: "31:0",
          desc: "Placeholder 32-bit field for extracted signal"
        }
      ]
    },
    {
      name: "fault_confinement_inc_one",
      desc: "Auto-extracted signal inc_one from fault_confinement.vhd",
      swaccess: "rw",
      hwaccess: "hrw",
      fields: [
        {
          name: "value",
          bits: "31:0",
          desc: "Placeholder 32-bit field for extracted signal"
        }
      ]
    },
    {
      name: "fault_confinement_inc_eight",
      desc: "Auto-extracted signal inc_eight from fault_confinement.vhd",
      swaccess: "rw",
      hwaccess: "hrw",
      fields: [
        {
          name: "value",
          bits: "31:0",
          desc: "Placeholder 32-bit field for extracted signal"
        }
      ]
    },
    {
      name: "fault_confinement_dec_one",
      desc: "Auto-extracted signal dec_one from fault_confinement.vhd",
      swaccess: "rw",
      hwaccess: "hrw",
      fields: [
        {
          name: "value",
          bits: "31:0",
          desc: "Placeholder 32-bit field for extracted signal"
        }
      ]
    },
    {
      name: "fault_confinement_drv_rom_ena",
      desc: "Auto-extracted signal drv_rom_ena from fault_confinement.vhd",
      swaccess: "rw",
      hwaccess: "hrw",
      fields: [
        {
          name: "value",
          bits: "31:0",
          desc: "Placeholder 32-bit field for extracted signal"
        }
      ]
    },
    {
      name: "fault_confinement_fsm_tx_err_ctr_mt_erp",
      desc: "Auto-extracted signal tx_err_ctr_mt_erp from fault_confinement_fsm.vhd",
      swaccess: "rw",
      hwaccess: "hrw",
      fields: [
        {
          name: "value",
          bits: "31:0",
          desc: "Placeholder 32-bit field for extracted signal"
        }
      ]
    },
    {
      name: "fault_confinement_fsm_rx_err_ctr_mt_erp",
      desc: "Auto-extracted signal rx_err_ctr_mt_erp from fault_confinement_fsm.vhd",
      swaccess: "rw",
      hwaccess: "hrw",
      fields: [
        {
          name: "value",
          bits: "31:0",
          desc: "Placeholder 32-bit field for extracted signal"
        }
      ]
    },
    {
      name: "fault_confinement_fsm_tx_err_ctr_mt_ewl",
      desc: "Auto-extracted signal tx_err_ctr_mt_ewl from fault_confinement_fsm.vhd",
      swaccess: "rw",
      hwaccess: "hrw",
      fields: [
        {
          name: "value",
          bits: "31:0",
          desc: "Placeholder 32-bit field for extracted signal"
        }
      ]
    },
    {
      name: "fault_confinement_fsm_rx_err_ctr_mt_ewl",
      desc: "Auto-extracted signal rx_err_ctr_mt_ewl from fault_confinement_fsm.vhd",
      swaccess: "rw",
      hwaccess: "hrw",
      fields: [
        {
          name: "value",
          bits: "31:0",
          desc: "Placeholder 32-bit field for extracted signal"
        }
      ]
    },
    {
      name: "fault_confinement_fsm_tx_err_ctr_mt_255",
      desc: "Auto-extracted signal tx_err_ctr_mt_255 from fault_confinement_fsm.vhd",
      swaccess: "rw",
      hwaccess: "hrw",
      fields: [
        {
          name: "value",
          bits: "31:0",
          desc: "Placeholder 32-bit field for extracted signal"
        }
      ]
    },
    {
      name: "fault_confinement_fsm_err_warning_limit_d",
      desc: "Auto-extracted signal err_warning_limit_d from fault_confinement_fsm.vhd",
      swaccess: "rw",
      hwaccess: "hrw",
      fields: [
        {
          name: "value",
          bits: "31:0",
          desc: "Placeholder 32-bit field for extracted signal"
        }
      ]
    },
    {
      name: "fault_confinement_fsm_err_warning_limit_q",
      desc: "Auto-extracted signal err_warning_limit_q from fault_confinement_fsm.vhd",
      swaccess: "rw",
      hwaccess: "hrw",
      fields: [
        {
          name: "value",
          bits: "31:0",
          desc: "Placeholder 32-bit field for extracted signal"
        }
      ]
    },
    {
      name: "fault_confinement_fsm_fc_fsm_res_d",
      desc: "Auto-extracted signal fc_fsm_res_d from fault_confinement_fsm.vhd",
      swaccess: "rw",
      hwaccess: "hrw",
      fields: [
        {
          name: "value",
          bits: "31:0",
          desc: "Placeholder 32-bit field for extracted signal"
        }
      ]
    },
    {
      name: "fault_confinement_fsm_fc_fsm_res_q",
      desc: "Auto-extracted signal fc_fsm_res_q from fault_confinement_fsm.vhd",
      swaccess: "rw",
      hwaccess: "hrw",
      fields: [
        {
          name: "value",
          bits: "31:0",
          desc: "Placeholder 32-bit field for extracted signal"
        }
      ]
    },
    {
      name: "fault_confinement_rules_inc_one_i",
      desc: "Auto-extracted signal inc_one_i from fault_confinement_rules.vhd",
      swaccess: "rw",
      hwaccess: "hrw",
      fields: [
        {
          name: "value",
          bits: "31:0",
          desc: "Placeholder 32-bit field for extracted signal"
        }
      ]
    },
    {
      name: "fault_confinement_rules_inc_eight_i",
      desc: "Auto-extracted signal inc_eight_i from fault_confinement_rules.vhd",
      swaccess: "rw",
      hwaccess: "hrw",
      fields: [
        {
          name: "value",
          bits: "31:0",
          desc: "Placeholder 32-bit field for extracted signal"
        }
      ]
    },
    {
      name: "frame_filters_drv_filter_A_mask",
      desc: "Auto-extracted signal drv_filter_A_mask from frame_filters.vhd",
      swaccess: "rw",
      hwaccess: "hrw",
      fields: [
        {
          name: "value",
          bits: "31:0",
          desc: "Placeholder 32-bit field for extracted signal"
        }
      ]
    },
    {
      name: "frame_filters_drv_filter_A_ctrl",
      desc: "Auto-extracted signal drv_filter_A_ctrl from frame_filters.vhd",
      swaccess: "rw",
      hwaccess: "hrw",
      fields: [
        {
          name: "value",
          bits: "31:0",
          desc: "Placeholder 32-bit field for extracted signal"
        }
      ]
    },
    {
      name: "frame_filters_drv_filter_A_bits",
      desc: "Auto-extracted signal drv_filter_A_bits from frame_filters.vhd",
      swaccess: "rw",
      hwaccess: "hrw",
      fields: [
        {
          name: "value",
          bits: "31:0",
          desc: "Placeholder 32-bit field for extracted signal"
        }
      ]
    },
    {
      name: "frame_filters_int_filter_A_valid",
      desc: "Auto-extracted signal int_filter_A_valid from frame_filters.vhd",
      swaccess: "rw",
      hwaccess: "hrw",
      fields: [
        {
          name: "value",
          bits: "31:0",
          desc: "Placeholder 32-bit field for extracted signal"
        }
      ]
    },
    {
      name: "frame_filters_drv_filter_B_mask",
      desc: "Auto-extracted signal drv_filter_B_mask from frame_filters.vhd",
      swaccess: "rw",
      hwaccess: "hrw",
      fields: [
        {
          name: "value",
          bits: "31:0",
          desc: "Placeholder 32-bit field for extracted signal"
        }
      ]
    },
    {
      name: "frame_filters_drv_filter_B_ctrl",
      desc: "Auto-extracted signal drv_filter_B_ctrl from frame_filters.vhd",
      swaccess: "rw",
      hwaccess: "hrw",
      fields: [
        {
          name: "value",
          bits: "31:0",
          desc: "Placeholder 32-bit field for extracted signal"
        }
      ]
    },
    {
      name: "frame_filters_drv_filter_B_bits",
      desc: "Auto-extracted signal drv_filter_B_bits from frame_filters.vhd",
      swaccess: "rw",
      hwaccess: "hrw",
      fields: [
        {
          name: "value",
          bits: "31:0",
          desc: "Placeholder 32-bit field for extracted signal"
        }
      ]
    },
    {
      name: "frame_filters_int_filter_B_valid",
      desc: "Auto-extracted signal int_filter_B_valid from frame_filters.vhd",
      swaccess: "rw",
      hwaccess: "hrw",
      fields: [
        {
          name: "value",
          bits: "31:0",
          desc: "Placeholder 32-bit field for extracted signal"
        }
      ]
    },
    {
      name: "frame_filters_drv_filter_C_mask",
      desc: "Auto-extracted signal drv_filter_C_mask from frame_filters.vhd",
      swaccess: "rw",
      hwaccess: "hrw",
      fields: [
        {
          name: "value",
          bits: "31:0",
          desc: "Placeholder 32-bit field for extracted signal"
        }
      ]
    },
    {
      name: "frame_filters_drv_filter_C_ctrl",
      desc: "Auto-extracted signal drv_filter_C_ctrl from frame_filters.vhd",
      swaccess: "rw",
      hwaccess: "hrw",
      fields: [
        {
          name: "value",
          bits: "31:0",
          desc: "Placeholder 32-bit field for extracted signal"
        }
      ]
    },
    {
      name: "frame_filters_drv_filter_C_bits",
      desc: "Auto-extracted signal drv_filter_C_bits from frame_filters.vhd",
      swaccess: "rw",
      hwaccess: "hrw",
      fields: [
        {
          name: "value",
          bits: "31:0",
          desc: "Placeholder 32-bit field for extracted signal"
        }
      ]
    },
    {
      name: "frame_filters_int_filter_C_valid",
      desc: "Auto-extracted signal int_filter_C_valid from frame_filters.vhd",
      swaccess: "rw",
      hwaccess: "hrw",
      fields: [
        {
          name: "value",
          bits: "31:0",
          desc: "Placeholder 32-bit field for extracted signal"
        }
      ]
    },
    {
      name: "frame_filters_drv_filter_ran_ctrl",
      desc: "Auto-extracted signal drv_filter_ran_ctrl from frame_filters.vhd",
      swaccess: "rw",
      hwaccess: "hrw",
      fields: [
        {
          name: "value",
          bits: "31:0",
          desc: "Placeholder 32-bit field for extracted signal"
        }
      ]
    },
    {
      name: "frame_filters_drv_filter_ran_lo_th",
      desc: "Auto-extracted signal drv_filter_ran_lo_th from frame_filters.vhd",
      swaccess: "rw",
      hwaccess: "hrw",
      fields: [
        {
          name: "value",
          bits: "31:0",
          desc: "Placeholder 32-bit field for extracted signal"
        }
      ]
    },
    {
      name: "frame_filters_drv_filter_ran_hi_th",
      desc: "Auto-extracted signal drv_filter_ran_hi_th from frame_filters.vhd",
      swaccess: "rw",
      hwaccess: "hrw",
      fields: [
        {
          name: "value",
          bits: "31:0",
          desc: "Placeholder 32-bit field for extracted signal"
        }
      ]
    },
    {
      name: "frame_filters_int_filter_ran_valid",
      desc: "Auto-extracted signal int_filter_ran_valid from frame_filters.vhd",
      swaccess: "rw",
      hwaccess: "hrw",
      fields: [
        {
          name: "value",
          bits: "31:0",
          desc: "Placeholder 32-bit field for extracted signal"
        }
      ]
    },
    {
      name: "frame_filters_drv_filters_ena",
      desc: "Auto-extracted signal drv_filters_ena from frame_filters.vhd",
      swaccess: "rw",
      hwaccess: "hrw",
      fields: [
        {
          name: "value",
          bits: "31:0",
          desc: "Placeholder 32-bit field for extracted signal"
        }
      ]
    },
    {
      name: "frame_filters_int_data_type",
      desc: "Auto-extracted signal int_data_type from frame_filters.vhd",
      swaccess: "rw",
      hwaccess: "hrw",
      fields: [
        {
          name: "value",
          bits: "31:0",
          desc: "Placeholder 32-bit field for extracted signal"
        }
      ]
    },
    {
      name: "frame_filters_int_data_ctrl",
      desc: "Auto-extracted signal int_data_ctrl from frame_filters.vhd",
      swaccess: "rw",
      hwaccess: "hrw",
      fields: [
        {
          name: "value",
          bits: "31:0",
          desc: "Placeholder 32-bit field for extracted signal"
        }
      ]
    },
    {
      name: "frame_filters_filter_A_enable",
      desc: "Auto-extracted signal filter_A_enable from frame_filters.vhd",
      swaccess: "rw",
      hwaccess: "hrw",
      fields: [
        {
          name: "value",
          bits: "31:0",
          desc: "Placeholder 32-bit field for extracted signal"
        }
      ]
    },
    {
      name: "frame_filters_filter_B_enable",
      desc: "Auto-extracted signal filter_B_enable from frame_filters.vhd",
      swaccess: "rw",
      hwaccess: "hrw",
      fields: [
        {
          name: "value",
          bits: "31:0",
          desc: "Placeholder 32-bit field for extracted signal"
        }
      ]
    },
    {
      name: "frame_filters_filter_C_enable",
      desc: "Auto-extracted signal filter_C_enable from frame_filters.vhd",
      swaccess: "rw",
      hwaccess: "hrw",
      fields: [
        {
          name: "value",
          bits: "31:0",
          desc: "Placeholder 32-bit field for extracted signal"
        }
      ]
    },
    {
      name: "frame_filters_filter_range_enable",
      desc: "Auto-extracted signal filter_range_enable from frame_filters.vhd",
      swaccess: "rw",
      hwaccess: "hrw",
      fields: [
        {
          name: "value",
          bits: "31:0",
          desc: "Placeholder 32-bit field for extracted signal"
        }
      ]
    },
    {
      name: "frame_filters_filter_result",
      desc: "Auto-extracted signal filter_result from frame_filters.vhd",
      swaccess: "rw",
      hwaccess: "hrw",
      fields: [
        {
          name: "value",
          bits: "31:0",
          desc: "Placeholder 32-bit field for extracted signal"
        }
      ]
    },
    {
      name: "frame_filters_ident_valid_d",
      desc: "Auto-extracted signal ident_valid_d from frame_filters.vhd",
      swaccess: "rw",
      hwaccess: "hrw",
      fields: [
        {
          name: "value",
          bits: "31:0",
          desc: "Placeholder 32-bit field for extracted signal"
        }
      ]
    },
    {
      name: "frame_filters_ident_valid_q",
      desc: "Auto-extracted signal ident_valid_q from frame_filters.vhd",
      swaccess: "rw",
      hwaccess: "hrw",
      fields: [
        {
          name: "value",
          bits: "31:0",
          desc: "Placeholder 32-bit field for extracted signal"
        }
      ]
    },
    {
      name: "frame_filters_drv_drop_remote_frames",
      desc: "Auto-extracted signal drv_drop_remote_frames from frame_filters.vhd",
      swaccess: "rw",
      hwaccess: "hrw",
      fields: [
        {
          name: "value",
          bits: "31:0",
          desc: "Placeholder 32-bit field for extracted signal"
        }
      ]
    },
    {
      name: "frame_filters_drop_rtr_frame",
      desc: "Auto-extracted signal drop_rtr_frame from frame_filters.vhd",
      swaccess: "rw",
      hwaccess: "hrw",
      fields: [
        {
          name: "value",
          bits: "31:0",
          desc: "Placeholder 32-bit field for extracted signal"
        }
      ]
    },
    {
      name: "inf_ram_wrapper_int_read_data",
      desc: "Auto-extracted signal int_read_data from inf_ram_wrapper.vhd",
      swaccess: "rw",
      hwaccess: "hrw",
      fields: [
        {
          name: "value",
          bits: "31:0",
          desc: "Placeholder 32-bit field for extracted signal"
        }
      ]
    },
    {
      name: "inf_ram_wrapper_byte_we",
      desc: "Auto-extracted signal byte_we from inf_ram_wrapper.vhd",
      swaccess: "rw",
      hwaccess: "hrw",
      fields: [
        {
          name: "value",
          bits: "31:0",
          desc: "Placeholder 32-bit field for extracted signal"
        }
      ]
    },
    {
      name: "int_manager_drv_int_vect_clr",
      desc: "Auto-extracted signal drv_int_vect_clr from int_manager.vhd",
      swaccess: "rw",
      hwaccess: "hrw",
      fields: [
        {
          name: "value",
          bits: "31:0",
          desc: "Placeholder 32-bit field for extracted signal"
        }
      ]
    },
    {
      name: "int_manager_drv_int_ena_set",
      desc: "Auto-extracted signal drv_int_ena_set from int_manager.vhd",
      swaccess: "rw",
      hwaccess: "hrw",
      fields: [
        {
          name: "value",
          bits: "31:0",
          desc: "Placeholder 32-bit field for extracted signal"
        }
      ]
    },
    {
      name: "int_manager_drv_int_ena_clr",
      desc: "Auto-extracted signal drv_int_ena_clr from int_manager.vhd",
      swaccess: "rw",
      hwaccess: "hrw",
      fields: [
        {
          name: "value",
          bits: "31:0",
          desc: "Placeholder 32-bit field for extracted signal"
        }
      ]
    },
    {
      name: "int_manager_drv_int_mask_set",
      desc: "Auto-extracted signal drv_int_mask_set from int_manager.vhd",
      swaccess: "rw",
      hwaccess: "hrw",
      fields: [
        {
          name: "value",
          bits: "31:0",
          desc: "Placeholder 32-bit field for extracted signal"
        }
      ]
    },
    {
      name: "int_manager_drv_int_mask_clr",
      desc: "Auto-extracted signal drv_int_mask_clr from int_manager.vhd",
      swaccess: "rw",
      hwaccess: "hrw",
      fields: [
        {
          name: "value",
          bits: "31:0",
          desc: "Placeholder 32-bit field for extracted signal"
        }
      ]
    },
    {
      name: "int_manager_int_ena_i",
      desc: "Auto-extracted signal int_ena_i from int_manager.vhd",
      swaccess: "rw",
      hwaccess: "hrw",
      fields: [
        {
          name: "value",
          bits: "31:0",
          desc: "Placeholder 32-bit field for extracted signal"
        }
      ]
    },
    {
      name: "int_manager_int_mask_i",
      desc: "Auto-extracted signal int_mask_i from int_manager.vhd",
      swaccess: "rw",
      hwaccess: "hrw",
      fields: [
        {
          name: "value",
          bits: "31:0",
          desc: "Placeholder 32-bit field for extracted signal"
        }
      ]
    },
    {
      name: "int_manager_int_vect_i",
      desc: "Auto-extracted signal int_vect_i from int_manager.vhd",
      swaccess: "rw",
      hwaccess: "hrw",
      fields: [
        {
          name: "value",
          bits: "31:0",
          desc: "Placeholder 32-bit field for extracted signal"
        }
      ]
    },
    {
      name: "int_manager_int_input_active",
      desc: "Auto-extracted signal int_input_active from int_manager.vhd",
      swaccess: "rw",
      hwaccess: "hrw",
      fields: [
        {
          name: "value",
          bits: "31:0",
          desc: "Placeholder 32-bit field for extracted signal"
        }
      ]
    },
    {
      name: "int_manager_int_i",
      desc: "Auto-extracted signal int_i from int_manager.vhd",
      swaccess: "rw",
      hwaccess: "hrw",
      fields: [
        {
          name: "value",
          bits: "31:0",
          desc: "Placeholder 32-bit field for extracted signal"
        }
      ]
    },
    {
      name: "int_module_int_mask_i",
      desc: "Auto-extracted signal int_mask_i from int_module.vhd",
      swaccess: "rw",
      hwaccess: "hrw",
      fields: [
        {
          name: "value",
          bits: "31:0",
          desc: "Placeholder 32-bit field for extracted signal"
        }
      ]
    },
    {
      name: "int_module_int_ena_i",
      desc: "Auto-extracted signal int_ena_i from int_module.vhd",
      swaccess: "rw",
      hwaccess: "hrw",
      fields: [
        {
          name: "value",
          bits: "31:0",
          desc: "Placeholder 32-bit field for extracted signal"
        }
      ]
    },
    {
      name: "int_module_int_mask_load",
      desc: "Auto-extracted signal int_mask_load from int_module.vhd",
      swaccess: "rw",
      hwaccess: "hrw",
      fields: [
        {
          name: "value",
          bits: "31:0",
          desc: "Placeholder 32-bit field for extracted signal"
        }
      ]
    },
    {
      name: "int_module_int_mask_next",
      desc: "Auto-extracted signal int_mask_next from int_module.vhd",
      swaccess: "rw",
      hwaccess: "hrw",
      fields: [
        {
          name: "value",
          bits: "31:0",
          desc: "Placeholder 32-bit field for extracted signal"
        }
      ]
    },
    {
      name: "memory_reg_reg_value_r",
      desc: "Auto-extracted signal reg_value_r from memory_reg.vhd",
      swaccess: "rw",
      hwaccess: "hrw",
      fields: [
        {
          name: "value",
          bits: "31:0",
          desc: "Placeholder 32-bit field for extracted signal"
        }
      ]
    },
    {
      name: "memory_reg_wr_select",
      desc: "Auto-extracted signal wr_select from memory_reg.vhd",
      swaccess: "rw",
      hwaccess: "hrw",
      fields: [
        {
          name: "value",
          bits: "31:0",
          desc: "Placeholder 32-bit field for extracted signal"
        }
      ]
    },
    {
      name: "memory_reg_wr_select_expanded",
      desc: "Auto-extracted signal wr_select_expanded from memory_reg.vhd",
      swaccess: "rw",
      hwaccess: "hrw",
      fields: [
        {
          name: "value",
          bits: "31:0",
          desc: "Placeholder 32-bit field for extracted signal"
        }
      ]
    },
    {
      name: "memory_registers_status_comb",
      desc: "Auto-extracted signal status_comb from memory_registers.vhd",
      swaccess: "rw",
      hwaccess: "hrw",
      fields: [
        {
          name: "value",
          bits: "31:0",
          desc: "Placeholder 32-bit field for extracted signal"
        }
      ]
    },
    {
      name: "memory_registers_can_core_cs",
      desc: "Auto-extracted signal can_core_cs from memory_registers.vhd",
      swaccess: "rw",
      hwaccess: "hrw",
      fields: [
        {
          name: "value",
          bits: "31:0",
          desc: "Placeholder 32-bit field for extracted signal"
        }
      ]
    },
    {
      name: "memory_registers_control_registers_cs",
      desc: "Auto-extracted signal control_registers_cs from memory_registers.vhd",
      swaccess: "rw",
      hwaccess: "hrw",
      fields: [
        {
          name: "value",
          bits: "31:0",
          desc: "Placeholder 32-bit field for extracted signal"
        }
      ]
    },
    {
      name: "memory_registers_control_registers_cs_reg",
      desc: "Auto-extracted signal control_registers_cs_reg from memory_registers.vhd",
      swaccess: "rw",
      hwaccess: "hrw",
      fields: [
        {
          name: "value",
          bits: "31:0",
          desc: "Placeholder 32-bit field for extracted signal"
        }
      ]
    },
    {
      name: "memory_registers_test_registers_cs",
      desc: "Auto-extracted signal test_registers_cs from memory_registers.vhd",
      swaccess: "rw",
      hwaccess: "hrw",
      fields: [
        {
          name: "value",
          bits: "31:0",
          desc: "Placeholder 32-bit field for extracted signal"
        }
      ]
    },
    {
      name: "memory_registers_test_registers_cs_reg",
      desc: "Auto-extracted signal test_registers_cs_reg from memory_registers.vhd",
      swaccess: "rw",
      hwaccess: "hrw",
      fields: [
        {
          name: "value",
          bits: "31:0",
          desc: "Placeholder 32-bit field for extracted signal"
        }
      ]
    },
    {
      name: "memory_registers_control_registers_rdata",
      desc: "Auto-extracted signal control_registers_rdata from memory_registers.vhd",
      swaccess: "rw",
      hwaccess: "hrw",
      fields: [
        {
          name: "value",
          bits: "31:0",
          desc: "Placeholder 32-bit field for extracted signal"
        }
      ]
    },
    {
      name: "memory_registers_test_registers_rdata",
      desc: "Auto-extracted signal test_registers_rdata from memory_registers.vhd",
      swaccess: "rw",
      hwaccess: "hrw",
      fields: [
        {
          name: "value",
          bits: "31:0",
          desc: "Placeholder 32-bit field for extracted signal"
        }
      ]
    },
    {
      name: "memory_registers_is_err_active",
      desc: "Auto-extracted signal is_err_active from memory_registers.vhd",
      swaccess: "rw",
      hwaccess: "hrw",
      fields: [
        {
          name: "value",
          bits: "31:0",
          desc: "Placeholder 32-bit field for extracted signal"
        }
      ]
    },
    {
      name: "memory_registers_is_err_passive",
      desc: "Auto-extracted signal is_err_passive from memory_registers.vhd",
      swaccess: "rw",
      hwaccess: "hrw",
      fields: [
        {
          name: "value",
          bits: "31:0",
          desc: "Placeholder 32-bit field for extracted signal"
        }
      ]
    },
    {
      name: "memory_registers_is_bus_off",
      desc: "Auto-extracted signal is_bus_off from memory_registers.vhd",
      swaccess: "rw",
      hwaccess: "hrw",
      fields: [
        {
          name: "value",
          bits: "31:0",
          desc: "Placeholder 32-bit field for extracted signal"
        }
      ]
    },
    {
      name: "memory_registers_is_transmitter",
      desc: "Auto-extracted signal is_transmitter from memory_registers.vhd",
      swaccess: "rw",
      hwaccess: "hrw",
      fields: [
        {
          name: "value",
          bits: "31:0",
          desc: "Placeholder 32-bit field for extracted signal"
        }
      ]
    },
    {
      name: "memory_registers_is_receiver",
      desc: "Auto-extracted signal is_receiver from memory_registers.vhd",
      swaccess: "rw",
      hwaccess: "hrw",
      fields: [
        {
          name: "value",
          bits: "31:0",
          desc: "Placeholder 32-bit field for extracted signal"
        }
      ]
    },
    {
      name: "memory_registers_is_idle",
      desc: "Auto-extracted signal is_idle from memory_registers.vhd",
      swaccess: "rw",
      hwaccess: "hrw",
      fields: [
        {
          name: "value",
          bits: "31:0",
          desc: "Placeholder 32-bit field for extracted signal"
        }
      ]
    },
    {
      name: "memory_registers_reg_lock_1_active",
      desc: "Auto-extracted signal reg_lock_1_active from memory_registers.vhd",
      swaccess: "rw",
      hwaccess: "hrw",
      fields: [
        {
          name: "value",
          bits: "31:0",
          desc: "Placeholder 32-bit field for extracted signal"
        }
      ]
    },
    {
      name: "memory_registers_reg_lock_2_active",
      desc: "Auto-extracted signal reg_lock_2_active from memory_registers.vhd",
      swaccess: "rw",
      hwaccess: "hrw",
      fields: [
        {
          name: "value",
          bits: "31:0",
          desc: "Placeholder 32-bit field for extracted signal"
        }
      ]
    },
    {
      name: "memory_registers_soft_res_q_n",
      desc: "Auto-extracted signal soft_res_q_n from memory_registers.vhd",
      swaccess: "rw",
      hwaccess: "hrw",
      fields: [
        {
          name: "value",
          bits: "31:0",
          desc: "Placeholder 32-bit field for extracted signal"
        }
      ]
    },
    {
      name: "memory_registers_ewl_padded",
      desc: "Auto-extracted signal ewl_padded from memory_registers.vhd",
      swaccess: "rw",
      hwaccess: "hrw",
      fields: [
        {
          name: "value",
          bits: "31:0",
          desc: "Placeholder 32-bit field for extracted signal"
        }
      ]
    },
    {
      name: "memory_registers_control_regs_clk_en",
      desc: "Auto-extracted signal control_regs_clk_en from memory_registers.vhd",
      swaccess: "rw",
      hwaccess: "hrw",
      fields: [
        {
          name: "value",
          bits: "31:0",
          desc: "Placeholder 32-bit field for extracted signal"
        }
      ]
    },
    {
      name: "memory_registers_test_regs_clk_en",
      desc: "Auto-extracted signal test_regs_clk_en from memory_registers.vhd",
      swaccess: "rw",
      hwaccess: "hrw",
      fields: [
        {
          name: "value",
          bits: "31:0",
          desc: "Placeholder 32-bit field for extracted signal"
        }
      ]
    },
    {
      name: "memory_registers_clk_control_regs",
      desc: "Auto-extracted signal clk_control_regs from memory_registers.vhd",
      swaccess: "rw",
      hwaccess: "hrw",
      fields: [
        {
          name: "value",
          bits: "31:0",
          desc: "Placeholder 32-bit field for extracted signal"
        }
      ]
    },
    {
      name: "memory_registers_clk_test_regs",
      desc: "Auto-extracted signal clk_test_regs from memory_registers.vhd",
      swaccess: "rw",
      hwaccess: "hrw",
      fields: [
        {
          name: "value",
          bits: "31:0",
          desc: "Placeholder 32-bit field for extracted signal"
        }
      ]
    },
    {
      name: "memory_registers_rx_buf_mode",
      desc: "Auto-extracted signal rx_buf_mode from memory_registers.vhd",
      swaccess: "rw",
      hwaccess: "hrw",
      fields: [
        {
          name: "value",
          bits: "31:0",
          desc: "Placeholder 32-bit field for extracted signal"
        }
      ]
    },
    {
      name: "memory_registers_rx_move_cmd",
      desc: "Auto-extracted signal rx_move_cmd from memory_registers.vhd",
      swaccess: "rw",
      hwaccess: "hrw",
      fields: [
        {
          name: "value",
          bits: "31:0",
          desc: "Placeholder 32-bit field for extracted signal"
        }
      ]
    },
    {
      name: "memory_registers_ctr_pres_sel_q",
      desc: "Auto-extracted signal ctr_pres_sel_q from memory_registers.vhd",
      swaccess: "rw",
      hwaccess: "hrw",
      fields: [
        {
          name: "value",
          bits: "31:0",
          desc: "Placeholder 32-bit field for extracted signal"
        }
      ]
    },
    {
      name: "operation_control_drv_ena",
      desc: "Auto-extracted signal drv_ena from operation_control.vhd",
      swaccess: "rw",
      hwaccess: "hrw",
      fields: [
        {
          name: "value",
          bits: "31:0",
          desc: "Placeholder 32-bit field for extracted signal"
        }
      ]
    },
    {
      name: "operation_control_go_to_off",
      desc: "Auto-extracted signal go_to_off from operation_control.vhd",
      swaccess: "rw",
      hwaccess: "hrw",
      fields: [
        {
          name: "value",
          bits: "31:0",
          desc: "Placeholder 32-bit field for extracted signal"
        }
      ]
    },
    {
      name: "prescaler_drv_ena",
      desc: "Auto-extracted signal drv_ena from prescaler.vhd",
      swaccess: "rw",
      hwaccess: "hrw",
      fields: [
        {
          name: "value",
          bits: "31:0",
          desc: "Placeholder 32-bit field for extracted signal"
        }
      ]
    },
    {
      name: "prescaler_tseg1_nbt",
      desc: "Auto-extracted signal tseg1_nbt from prescaler.vhd",
      swaccess: "rw",
      hwaccess: "hrw",
      fields: [
        {
          name: "value",
          bits: "31:0",
          desc: "Placeholder 32-bit field for extracted signal"
        }
      ]
    },
    {
      name: "prescaler_tseg2_nbt",
      desc: "Auto-extracted signal tseg2_nbt from prescaler.vhd",
      swaccess: "rw",
      hwaccess: "hrw",
      fields: [
        {
          name: "value",
          bits: "31:0",
          desc: "Placeholder 32-bit field for extracted signal"
        }
      ]
    },
    {
      name: "prescaler_brp_nbt",
      desc: "Auto-extracted signal brp_nbt from prescaler.vhd",
      swaccess: "rw",
      hwaccess: "hrw",
      fields: [
        {
          name: "value",
          bits: "31:0",
          desc: "Placeholder 32-bit field for extracted signal"
        }
      ]
    },
    {
      name: "prescaler_sjw_nbt",
      desc: "Auto-extracted signal sjw_nbt from prescaler.vhd",
      swaccess: "rw",
      hwaccess: "hrw",
      fields: [
        {
          name: "value",
          bits: "31:0",
          desc: "Placeholder 32-bit field for extracted signal"
        }
      ]
    },
    {
      name: "prescaler_tseg1_dbt",
      desc: "Auto-extracted signal tseg1_dbt from prescaler.vhd",
      swaccess: "rw",
      hwaccess: "hrw",
      fields: [
        {
          name: "value",
          bits: "31:0",
          desc: "Placeholder 32-bit field for extracted signal"
        }
      ]
    },
    {
      name: "prescaler_tseg2_dbt",
      desc: "Auto-extracted signal tseg2_dbt from prescaler.vhd",
      swaccess: "rw",
      hwaccess: "hrw",
      fields: [
        {
          name: "value",
          bits: "31:0",
          desc: "Placeholder 32-bit field for extracted signal"
        }
      ]
    },
    {
      name: "prescaler_brp_dbt",
      desc: "Auto-extracted signal brp_dbt from prescaler.vhd",
      swaccess: "rw",
      hwaccess: "hrw",
      fields: [
        {
          name: "value",
          bits: "31:0",
          desc: "Placeholder 32-bit field for extracted signal"
        }
      ]
    },
    {
      name: "prescaler_sjw_dbt",
      desc: "Auto-extracted signal sjw_dbt from prescaler.vhd",
      swaccess: "rw",
      hwaccess: "hrw",
      fields: [
        {
          name: "value",
          bits: "31:0",
          desc: "Placeholder 32-bit field for extracted signal"
        }
      ]
    },
    {
      name: "prescaler_segment_end",
      desc: "Auto-extracted signal segment_end from prescaler.vhd",
      swaccess: "rw",
      hwaccess: "hrw",
      fields: [
        {
          name: "value",
          bits: "31:0",
          desc: "Placeholder 32-bit field for extracted signal"
        }
      ]
    },
    {
      name: "prescaler_h_sync_valid",
      desc: "Auto-extracted signal h_sync_valid from prescaler.vhd",
      swaccess: "rw",
      hwaccess: "hrw",
      fields: [
        {
          name: "value",
          bits: "31:0",
          desc: "Placeholder 32-bit field for extracted signal"
        }
      ]
    },
    {
      name: "prescaler_is_tseg1",
      desc: "Auto-extracted signal is_tseg1 from prescaler.vhd",
      swaccess: "rw",
      hwaccess: "hrw",
      fields: [
        {
          name: "value",
          bits: "31:0",
          desc: "Placeholder 32-bit field for extracted signal"
        }
      ]
    },
    {
      name: "prescaler_is_tseg2",
      desc: "Auto-extracted signal is_tseg2 from prescaler.vhd",
      swaccess: "rw",
      hwaccess: "hrw",
      fields: [
        {
          name: "value",
          bits: "31:0",
          desc: "Placeholder 32-bit field for extracted signal"
        }
      ]
    },
    {
      name: "prescaler_resync_edge_valid",
      desc: "Auto-extracted signal resync_edge_valid from prescaler.vhd",
      swaccess: "rw",
      hwaccess: "hrw",
      fields: [
        {
          name: "value",
          bits: "31:0",
          desc: "Placeholder 32-bit field for extracted signal"
        }
      ]
    },
    {
      name: "prescaler_h_sync_edge_valid",
      desc: "Auto-extracted signal h_sync_edge_valid from prescaler.vhd",
      swaccess: "rw",
      hwaccess: "hrw",
      fields: [
        {
          name: "value",
          bits: "31:0",
          desc: "Placeholder 32-bit field for extracted signal"
        }
      ]
    },
    {
      name: "prescaler_segm_counter_nbt",
      desc: "Auto-extracted signal segm_counter_nbt from prescaler.vhd",
      swaccess: "rw",
      hwaccess: "hrw",
      fields: [
        {
          name: "value",
          bits: "31:0",
          desc: "Placeholder 32-bit field for extracted signal"
        }
      ]
    },
    {
      name: "prescaler_segm_counter_dbt",
      desc: "Auto-extracted signal segm_counter_dbt from prescaler.vhd",
      swaccess: "rw",
      hwaccess: "hrw",
      fields: [
        {
          name: "value",
          bits: "31:0",
          desc: "Placeholder 32-bit field for extracted signal"
        }
      ]
    },
    {
      name: "prescaler_exit_segm_req_nbt",
      desc: "Auto-extracted signal exit_segm_req_nbt from prescaler.vhd",
      swaccess: "rw",
      hwaccess: "hrw",
      fields: [
        {
          name: "value",
          bits: "31:0",
          desc: "Placeholder 32-bit field for extracted signal"
        }
      ]
    },
    {
      name: "prescaler_exit_segm_req_dbt",
      desc: "Auto-extracted signal exit_segm_req_dbt from prescaler.vhd",
      swaccess: "rw",
      hwaccess: "hrw",
      fields: [
        {
          name: "value",
          bits: "31:0",
          desc: "Placeholder 32-bit field for extracted signal"
        }
      ]
    },
    {
      name: "prescaler_tq_edge_nbt",
      desc: "Auto-extracted signal tq_edge_nbt from prescaler.vhd",
      swaccess: "rw",
      hwaccess: "hrw",
      fields: [
        {
          name: "value",
          bits: "31:0",
          desc: "Placeholder 32-bit field for extracted signal"
        }
      ]
    },
    {
      name: "prescaler_tq_edge_dbt",
      desc: "Auto-extracted signal tq_edge_dbt from prescaler.vhd",
      swaccess: "rw",
      hwaccess: "hrw",
      fields: [
        {
          name: "value",
          bits: "31:0",
          desc: "Placeholder 32-bit field for extracted signal"
        }
      ]
    },
    {
      name: "prescaler_rx_trig_req",
      desc: "Auto-extracted signal rx_trig_req from prescaler.vhd",
      swaccess: "rw",
      hwaccess: "hrw",
      fields: [
        {
          name: "value",
          bits: "31:0",
          desc: "Placeholder 32-bit field for extracted signal"
        }
      ]
    },
    {
      name: "prescaler_tx_trig_req",
      desc: "Auto-extracted signal tx_trig_req from prescaler.vhd",
      swaccess: "rw",
      hwaccess: "hrw",
      fields: [
        {
          name: "value",
          bits: "31:0",
          desc: "Placeholder 32-bit field for extracted signal"
        }
      ]
    },
    {
      name: "prescaler_start_edge",
      desc: "Auto-extracted signal start_edge from prescaler.vhd",
      swaccess: "rw",
      hwaccess: "hrw",
      fields: [
        {
          name: "value",
          bits: "31:0",
          desc: "Placeholder 32-bit field for extracted signal"
        }
      ]
    },
    {
      name: "prescaler_bt_ctr_clear",
      desc: "Auto-extracted signal bt_ctr_clear from prescaler.vhd",
      swaccess: "rw",
      hwaccess: "hrw",
      fields: [
        {
          name: "value",
          bits: "31:0",
          desc: "Placeholder 32-bit field for extracted signal"
        }
      ]
    },
    {
      name: "priority_decoder_l0_valid",
      desc: "Auto-extracted signal l0_valid from priority_decoder.vhd",
      swaccess: "rw",
      hwaccess: "hrw",
      fields: [
        {
          name: "value",
          bits: "31:0",
          desc: "Placeholder 32-bit field for extracted signal"
        }
      ]
    },
    {
      name: "priority_decoder_l1_valid",
      desc: "Auto-extracted signal l1_valid from priority_decoder.vhd",
      swaccess: "rw",
      hwaccess: "hrw",
      fields: [
        {
          name: "value",
          bits: "31:0",
          desc: "Placeholder 32-bit field for extracted signal"
        }
      ]
    },
    {
      name: "priority_decoder_l1_winner",
      desc: "Auto-extracted signal l1_winner from priority_decoder.vhd",
      swaccess: "rw",
      hwaccess: "hrw",
      fields: [
        {
          name: "value",
          bits: "31:0",
          desc: "Placeholder 32-bit field for extracted signal"
        }
      ]
    },
    {
      name: "priority_decoder_l2_valid",
      desc: "Auto-extracted signal l2_valid from priority_decoder.vhd",
      swaccess: "rw",
      hwaccess: "hrw",
      fields: [
        {
          name: "value",
          bits: "31:0",
          desc: "Placeholder 32-bit field for extracted signal"
        }
      ]
    },
    {
      name: "priority_decoder_l2_winner",
      desc: "Auto-extracted signal l2_winner from priority_decoder.vhd",
      swaccess: "rw",
      hwaccess: "hrw",
      fields: [
        {
          name: "value",
          bits: "31:0",
          desc: "Placeholder 32-bit field for extracted signal"
        }
      ]
    },
    {
      name: "priority_decoder_l3_valid",
      desc: "Auto-extracted signal l3_valid from priority_decoder.vhd",
      swaccess: "rw",
      hwaccess: "hrw",
      fields: [
        {
          name: "value",
          bits: "31:0",
          desc: "Placeholder 32-bit field for extracted signal"
        }
      ]
    },
    {
      name: "priority_decoder_l3_winner",
      desc: "Auto-extracted signal l3_winner from priority_decoder.vhd",
      swaccess: "rw",
      hwaccess: "hrw",
      fields: [
        {
          name: "value",
          bits: "31:0",
          desc: "Placeholder 32-bit field for extracted signal"
        }
      ]
    },
    {
      name: "protocol_control_drv_can_fd_ena",
      desc: "Auto-extracted signal drv_can_fd_ena from protocol_control.vhd",
      swaccess: "rw",
      hwaccess: "hrw",
      fields: [
        {
          name: "value",
          bits: "31:0",
          desc: "Placeholder 32-bit field for extracted signal"
        }
      ]
    },
    {
      name: "protocol_control_drv_bus_mon_ena",
      desc: "Auto-extracted signal drv_bus_mon_ena from protocol_control.vhd",
      swaccess: "rw",
      hwaccess: "hrw",
      fields: [
        {
          name: "value",
          bits: "31:0",
          desc: "Placeholder 32-bit field for extracted signal"
        }
      ]
    },
    {
      name: "protocol_control_drv_retr_lim_ena",
      desc: "Auto-extracted signal drv_retr_lim_ena from protocol_control.vhd",
      swaccess: "rw",
      hwaccess: "hrw",
      fields: [
        {
          name: "value",
          bits: "31:0",
          desc: "Placeholder 32-bit field for extracted signal"
        }
      ]
    },
    {
      name: "protocol_control_drv_retr_th",
      desc: "Auto-extracted signal drv_retr_th from protocol_control.vhd",
      swaccess: "rw",
      hwaccess: "hrw",
      fields: [
        {
          name: "value",
          bits: "31:0",
          desc: "Placeholder 32-bit field for extracted signal"
        }
      ]
    },
    {
      name: "protocol_control_drv_self_test_ena",
      desc: "Auto-extracted signal drv_self_test_ena from protocol_control.vhd",
      swaccess: "rw",
      hwaccess: "hrw",
      fields: [
        {
          name: "value",
          bits: "31:0",
          desc: "Placeholder 32-bit field for extracted signal"
        }
      ]
    },
    {
      name: "protocol_control_drv_ack_forb",
      desc: "Auto-extracted signal drv_ack_forb from protocol_control.vhd",
      swaccess: "rw",
      hwaccess: "hrw",
      fields: [
        {
          name: "value",
          bits: "31:0",
          desc: "Placeholder 32-bit field for extracted signal"
        }
      ]
    },
    {
      name: "protocol_control_drv_ena",
      desc: "Auto-extracted signal drv_ena from protocol_control.vhd",
      swaccess: "rw",
      hwaccess: "hrw",
      fields: [
        {
          name: "value",
          bits: "31:0",
          desc: "Placeholder 32-bit field for extracted signal"
        }
      ]
    },
    {
      name: "protocol_control_drv_fd_type",
      desc: "Auto-extracted signal drv_fd_type from protocol_control.vhd",
      swaccess: "rw",
      hwaccess: "hrw",
      fields: [
        {
          name: "value",
          bits: "31:0",
          desc: "Placeholder 32-bit field for extracted signal"
        }
      ]
    },
    {
      name: "protocol_control_drv_int_loopback_ena",
      desc: "Auto-extracted signal drv_int_loopback_ena from protocol_control.vhd",
      swaccess: "rw",
      hwaccess: "hrw",
      fields: [
        {
          name: "value",
          bits: "31:0",
          desc: "Placeholder 32-bit field for extracted signal"
        }
      ]
    },
    {
      name: "protocol_control_drv_bus_off_reset",
      desc: "Auto-extracted signal drv_bus_off_reset from protocol_control.vhd",
      swaccess: "rw",
      hwaccess: "hrw",
      fields: [
        {
          name: "value",
          bits: "31:0",
          desc: "Placeholder 32-bit field for extracted signal"
        }
      ]
    },
    {
      name: "protocol_control_drv_ssp_delay_select",
      desc: "Auto-extracted signal drv_ssp_delay_select from protocol_control.vhd",
      swaccess: "rw",
      hwaccess: "hrw",
      fields: [
        {
          name: "value",
          bits: "31:0",
          desc: "Placeholder 32-bit field for extracted signal"
        }
      ]
    },
    {
      name: "protocol_control_drv_pex",
      desc: "Auto-extracted signal drv_pex from protocol_control.vhd",
      swaccess: "rw",
      hwaccess: "hrw",
      fields: [
        {
          name: "value",
          bits: "31:0",
          desc: "Placeholder 32-bit field for extracted signal"
        }
      ]
    },
    {
      name: "protocol_control_drv_cpexs",
      desc: "Auto-extracted signal drv_cpexs from protocol_control.vhd",
      swaccess: "rw",
      hwaccess: "hrw",
      fields: [
        {
          name: "value",
          bits: "31:0",
          desc: "Placeholder 32-bit field for extracted signal"
        }
      ]
    },
    {
      name: "protocol_control_tran_word_swapped",
      desc: "Auto-extracted signal tran_word_swapped from protocol_control.vhd",
      swaccess: "rw",
      hwaccess: "hrw",
      fields: [
        {
          name: "value",
          bits: "31:0",
          desc: "Placeholder 32-bit field for extracted signal"
        }
      ]
    },
    {
      name: "protocol_control_err_frm_req",
      desc: "Auto-extracted signal err_frm_req from protocol_control.vhd",
      swaccess: "rw",
      hwaccess: "hrw",
      fields: [
        {
          name: "value",
          bits: "31:0",
          desc: "Placeholder 32-bit field for extracted signal"
        }
      ]
    },
    {
      name: "protocol_control_tx_load_base_id",
      desc: "Auto-extracted signal tx_load_base_id from protocol_control.vhd",
      swaccess: "rw",
      hwaccess: "hrw",
      fields: [
        {
          name: "value",
          bits: "31:0",
          desc: "Placeholder 32-bit field for extracted signal"
        }
      ]
    },
    {
      name: "protocol_control_tx_load_ext_id",
      desc: "Auto-extracted signal tx_load_ext_id from protocol_control.vhd",
      swaccess: "rw",
      hwaccess: "hrw",
      fields: [
        {
          name: "value",
          bits: "31:0",
          desc: "Placeholder 32-bit field for extracted signal"
        }
      ]
    },
    {
      name: "protocol_control_tx_load_dlc",
      desc: "Auto-extracted signal tx_load_dlc from protocol_control.vhd",
      swaccess: "rw",
      hwaccess: "hrw",
      fields: [
        {
          name: "value",
          bits: "31:0",
          desc: "Placeholder 32-bit field for extracted signal"
        }
      ]
    },
    {
      name: "protocol_control_tx_load_data_word",
      desc: "Auto-extracted signal tx_load_data_word from protocol_control.vhd",
      swaccess: "rw",
      hwaccess: "hrw",
      fields: [
        {
          name: "value",
          bits: "31:0",
          desc: "Placeholder 32-bit field for extracted signal"
        }
      ]
    },
    {
      name: "protocol_control_tx_load_stuff_count",
      desc: "Auto-extracted signal tx_load_stuff_count from protocol_control.vhd",
      swaccess: "rw",
      hwaccess: "hrw",
      fields: [
        {
          name: "value",
          bits: "31:0",
          desc: "Placeholder 32-bit field for extracted signal"
        }
      ]
    },
    {
      name: "protocol_control_tx_load_crc",
      desc: "Auto-extracted signal tx_load_crc from protocol_control.vhd",
      swaccess: "rw",
      hwaccess: "hrw",
      fields: [
        {
          name: "value",
          bits: "31:0",
          desc: "Placeholder 32-bit field for extracted signal"
        }
      ]
    },
    {
      name: "protocol_control_tx_shift_ena",
      desc: "Auto-extracted signal tx_shift_ena from protocol_control.vhd",
      swaccess: "rw",
      hwaccess: "hrw",
      fields: [
        {
          name: "value",
          bits: "31:0",
          desc: "Placeholder 32-bit field for extracted signal"
        }
      ]
    },
    {
      name: "protocol_control_tx_dominant",
      desc: "Auto-extracted signal tx_dominant from protocol_control.vhd",
      swaccess: "rw",
      hwaccess: "hrw",
      fields: [
        {
          name: "value",
          bits: "31:0",
          desc: "Placeholder 32-bit field for extracted signal"
        }
      ]
    },
    {
      name: "protocol_control_rx_clear",
      desc: "Auto-extracted signal rx_clear from protocol_control.vhd",
      swaccess: "rw",
      hwaccess: "hrw",
      fields: [
        {
          name: "value",
          bits: "31:0",
          desc: "Placeholder 32-bit field for extracted signal"
        }
      ]
    },
    {
      name: "protocol_control_rx_store_base_id",
      desc: "Auto-extracted signal rx_store_base_id from protocol_control.vhd",
      swaccess: "rw",
      hwaccess: "hrw",
      fields: [
        {
          name: "value",
          bits: "31:0",
          desc: "Placeholder 32-bit field for extracted signal"
        }
      ]
    },
    {
      name: "protocol_control_rx_store_ext_id",
      desc: "Auto-extracted signal rx_store_ext_id from protocol_control.vhd",
      swaccess: "rw",
      hwaccess: "hrw",
      fields: [
        {
          name: "value",
          bits: "31:0",
          desc: "Placeholder 32-bit field for extracted signal"
        }
      ]
    },
    {
      name: "protocol_control_rx_store_ide",
      desc: "Auto-extracted signal rx_store_ide from protocol_control.vhd",
      swaccess: "rw",
      hwaccess: "hrw",
      fields: [
        {
          name: "value",
          bits: "31:0",
          desc: "Placeholder 32-bit field for extracted signal"
        }
      ]
    },
    {
      name: "protocol_control_rx_store_rtr",
      desc: "Auto-extracted signal rx_store_rtr from protocol_control.vhd",
      swaccess: "rw",
      hwaccess: "hrw",
      fields: [
        {
          name: "value",
          bits: "31:0",
          desc: "Placeholder 32-bit field for extracted signal"
        }
      ]
    },
    {
      name: "protocol_control_rx_store_edl",
      desc: "Auto-extracted signal rx_store_edl from protocol_control.vhd",
      swaccess: "rw",
      hwaccess: "hrw",
      fields: [
        {
          name: "value",
          bits: "31:0",
          desc: "Placeholder 32-bit field for extracted signal"
        }
      ]
    },
    {
      name: "protocol_control_rx_store_dlc",
      desc: "Auto-extracted signal rx_store_dlc from protocol_control.vhd",
      swaccess: "rw",
      hwaccess: "hrw",
      fields: [
        {
          name: "value",
          bits: "31:0",
          desc: "Placeholder 32-bit field for extracted signal"
        }
      ]
    },
    {
      name: "protocol_control_rx_store_esi",
      desc: "Auto-extracted signal rx_store_esi from protocol_control.vhd",
      swaccess: "rw",
      hwaccess: "hrw",
      fields: [
        {
          name: "value",
          bits: "31:0",
          desc: "Placeholder 32-bit field for extracted signal"
        }
      ]
    },
    {
      name: "protocol_control_rx_store_brs",
      desc: "Auto-extracted signal rx_store_brs from protocol_control.vhd",
      swaccess: "rw",
      hwaccess: "hrw",
      fields: [
        {
          name: "value",
          bits: "31:0",
          desc: "Placeholder 32-bit field for extracted signal"
        }
      ]
    },
    {
      name: "protocol_control_rx_store_stuff_count",
      desc: "Auto-extracted signal rx_store_stuff_count from protocol_control.vhd",
      swaccess: "rw",
      hwaccess: "hrw",
      fields: [
        {
          name: "value",
          bits: "31:0",
          desc: "Placeholder 32-bit field for extracted signal"
        }
      ]
    },
    {
      name: "protocol_control_rx_shift_ena",
      desc: "Auto-extracted signal rx_shift_ena from protocol_control.vhd",
      swaccess: "rw",
      hwaccess: "hrw",
      fields: [
        {
          name: "value",
          bits: "31:0",
          desc: "Placeholder 32-bit field for extracted signal"
        }
      ]
    },
    {
      name: "protocol_control_rx_shift_in_sel",
      desc: "Auto-extracted signal rx_shift_in_sel from protocol_control.vhd",
      swaccess: "rw",
      hwaccess: "hrw",
      fields: [
        {
          name: "value",
          bits: "31:0",
          desc: "Placeholder 32-bit field for extracted signal"
        }
      ]
    },
    {
      name: "protocol_control_rec_is_rtr_i",
      desc: "Auto-extracted signal rec_is_rtr_i from protocol_control.vhd",
      swaccess: "rw",
      hwaccess: "hrw",
      fields: [
        {
          name: "value",
          bits: "31:0",
          desc: "Placeholder 32-bit field for extracted signal"
        }
      ]
    },
    {
      name: "protocol_control_rec_dlc_d",
      desc: "Auto-extracted signal rec_dlc_d from protocol_control.vhd",
      swaccess: "rw",
      hwaccess: "hrw",
      fields: [
        {
          name: "value",
          bits: "31:0",
          desc: "Placeholder 32-bit field for extracted signal"
        }
      ]
    },
    {
      name: "protocol_control_rec_dlc_q",
      desc: "Auto-extracted signal rec_dlc_q from protocol_control.vhd",
      swaccess: "rw",
      hwaccess: "hrw",
      fields: [
        {
          name: "value",
          bits: "31:0",
          desc: "Placeholder 32-bit field for extracted signal"
        }
      ]
    },
    {
      name: "protocol_control_rec_frame_type_i",
      desc: "Auto-extracted signal rec_frame_type_i from protocol_control.vhd",
      swaccess: "rw",
      hwaccess: "hrw",
      fields: [
        {
          name: "value",
          bits: "31:0",
          desc: "Placeholder 32-bit field for extracted signal"
        }
      ]
    },
    {
      name: "protocol_control_ctrl_ctr_pload",
      desc: "Auto-extracted signal ctrl_ctr_pload from protocol_control.vhd",
      swaccess: "rw",
      hwaccess: "hrw",
      fields: [
        {
          name: "value",
          bits: "31:0",
          desc: "Placeholder 32-bit field for extracted signal"
        }
      ]
    },
    {
      name: "protocol_control_ctrl_ctr_pload_val",
      desc: "Auto-extracted signal ctrl_ctr_pload_val from protocol_control.vhd",
      swaccess: "rw",
      hwaccess: "hrw",
      fields: [
        {
          name: "value",
          bits: "31:0",
          desc: "Placeholder 32-bit field for extracted signal"
        }
      ]
    },
    {
      name: "protocol_control_ctrl_ctr_ena",
      desc: "Auto-extracted signal ctrl_ctr_ena from protocol_control.vhd",
      swaccess: "rw",
      hwaccess: "hrw",
      fields: [
        {
          name: "value",
          bits: "31:0",
          desc: "Placeholder 32-bit field for extracted signal"
        }
      ]
    },
    {
      name: "protocol_control_ctrl_ctr_zero",
      desc: "Auto-extracted signal ctrl_ctr_zero from protocol_control.vhd",
      swaccess: "rw",
      hwaccess: "hrw",
      fields: [
        {
          name: "value",
          bits: "31:0",
          desc: "Placeholder 32-bit field for extracted signal"
        }
      ]
    },
    {
      name: "protocol_control_ctrl_ctr_one",
      desc: "Auto-extracted signal ctrl_ctr_one from protocol_control.vhd",
      swaccess: "rw",
      hwaccess: "hrw",
      fields: [
        {
          name: "value",
          bits: "31:0",
          desc: "Placeholder 32-bit field for extracted signal"
        }
      ]
    },
    {
      name: "protocol_control_ctrl_counted_byte",
      desc: "Auto-extracted signal ctrl_counted_byte from protocol_control.vhd",
      swaccess: "rw",
      hwaccess: "hrw",
      fields: [
        {
          name: "value",
          bits: "31:0",
          desc: "Placeholder 32-bit field for extracted signal"
        }
      ]
    },
    {
      name: "protocol_control_ctrl_counted_byte_index",
      desc: "Auto-extracted signal ctrl_counted_byte_index from protocol_control.vhd",
      swaccess: "rw",
      hwaccess: "hrw",
      fields: [
        {
          name: "value",
          bits: "31:0",
          desc: "Placeholder 32-bit field for extracted signal"
        }
      ]
    },
    {
      name: "protocol_control_ctrl_ctr_mem_index",
      desc: "Auto-extracted signal ctrl_ctr_mem_index from protocol_control.vhd",
      swaccess: "rw",
      hwaccess: "hrw",
      fields: [
        {
          name: "value",
          bits: "31:0",
          desc: "Placeholder 32-bit field for extracted signal"
        }
      ]
    },
    {
      name: "protocol_control_compl_ctr_ena",
      desc: "Auto-extracted signal compl_ctr_ena from protocol_control.vhd",
      swaccess: "rw",
      hwaccess: "hrw",
      fields: [
        {
          name: "value",
          bits: "31:0",
          desc: "Placeholder 32-bit field for extracted signal"
        }
      ]
    },
    {
      name: "protocol_control_reinteg_ctr_clr",
      desc: "Auto-extracted signal reinteg_ctr_clr from protocol_control.vhd",
      swaccess: "rw",
      hwaccess: "hrw",
      fields: [
        {
          name: "value",
          bits: "31:0",
          desc: "Placeholder 32-bit field for extracted signal"
        }
      ]
    },
    {
      name: "protocol_control_reinteg_ctr_enable",
      desc: "Auto-extracted signal reinteg_ctr_enable from protocol_control.vhd",
      swaccess: "rw",
      hwaccess: "hrw",
      fields: [
        {
          name: "value",
          bits: "31:0",
          desc: "Placeholder 32-bit field for extracted signal"
        }
      ]
    },
    {
      name: "protocol_control_reinteg_ctr_expired",
      desc: "Auto-extracted signal reinteg_ctr_expired from protocol_control.vhd",
      swaccess: "rw",
      hwaccess: "hrw",
      fields: [
        {
          name: "value",
          bits: "31:0",
          desc: "Placeholder 32-bit field for extracted signal"
        }
      ]
    },
    {
      name: "protocol_control_retr_ctr_clear",
      desc: "Auto-extracted signal retr_ctr_clear from protocol_control.vhd",
      swaccess: "rw",
      hwaccess: "hrw",
      fields: [
        {
          name: "value",
          bits: "31:0",
          desc: "Placeholder 32-bit field for extracted signal"
        }
      ]
    },
    {
      name: "protocol_control_retr_ctr_add",
      desc: "Auto-extracted signal retr_ctr_add from protocol_control.vhd",
      swaccess: "rw",
      hwaccess: "hrw",
      fields: [
        {
          name: "value",
          bits: "31:0",
          desc: "Placeholder 32-bit field for extracted signal"
        }
      ]
    },
    {
      name: "protocol_control_retr_limit_reached",
      desc: "Auto-extracted signal retr_limit_reached from protocol_control.vhd",
      swaccess: "rw",
      hwaccess: "hrw",
      fields: [
        {
          name: "value",
          bits: "31:0",
          desc: "Placeholder 32-bit field for extracted signal"
        }
      ]
    },
    {
      name: "protocol_control_form_err_i",
      desc: "Auto-extracted signal form_err_i from protocol_control.vhd",
      swaccess: "rw",
      hwaccess: "hrw",
      fields: [
        {
          name: "value",
          bits: "31:0",
          desc: "Placeholder 32-bit field for extracted signal"
        }
      ]
    },
    {
      name: "protocol_control_ack_err_i",
      desc: "Auto-extracted signal ack_err_i from protocol_control.vhd",
      swaccess: "rw",
      hwaccess: "hrw",
      fields: [
        {
          name: "value",
          bits: "31:0",
          desc: "Placeholder 32-bit field for extracted signal"
        }
      ]
    },
    {
      name: "protocol_control_crc_check",
      desc: "Auto-extracted signal crc_check from protocol_control.vhd",
      swaccess: "rw",
      hwaccess: "hrw",
      fields: [
        {
          name: "value",
          bits: "31:0",
          desc: "Placeholder 32-bit field for extracted signal"
        }
      ]
    },
    {
      name: "protocol_control_bit_err_arb",
      desc: "Auto-extracted signal bit_err_arb from protocol_control.vhd",
      swaccess: "rw",
      hwaccess: "hrw",
      fields: [
        {
          name: "value",
          bits: "31:0",
          desc: "Placeholder 32-bit field for extracted signal"
        }
      ]
    },
    {
      name: "protocol_control_crc_match",
      desc: "Auto-extracted signal crc_match from protocol_control.vhd",
      swaccess: "rw",
      hwaccess: "hrw",
      fields: [
        {
          name: "value",
          bits: "31:0",
          desc: "Placeholder 32-bit field for extracted signal"
        }
      ]
    },
    {
      name: "protocol_control_crc_err_i",
      desc: "Auto-extracted signal crc_err_i from protocol_control.vhd",
      swaccess: "rw",
      hwaccess: "hrw",
      fields: [
        {
          name: "value",
          bits: "31:0",
          desc: "Placeholder 32-bit field for extracted signal"
        }
      ]
    },
    {
      name: "protocol_control_crc_clear_match_flag",
      desc: "Auto-extracted signal crc_clear_match_flag from protocol_control.vhd",
      swaccess: "rw",
      hwaccess: "hrw",
      fields: [
        {
          name: "value",
          bits: "31:0",
          desc: "Placeholder 32-bit field for extracted signal"
        }
      ]
    },
    {
      name: "protocol_control_crc_src",
      desc: "Auto-extracted signal crc_src from protocol_control.vhd",
      swaccess: "rw",
      hwaccess: "hrw",
      fields: [
        {
          name: "value",
          bits: "31:0",
          desc: "Placeholder 32-bit field for extracted signal"
        }
      ]
    },
    {
      name: "protocol_control_err_pos",
      desc: "Auto-extracted signal err_pos from protocol_control.vhd",
      swaccess: "rw",
      hwaccess: "hrw",
      fields: [
        {
          name: "value",
          bits: "31:0",
          desc: "Placeholder 32-bit field for extracted signal"
        }
      ]
    },
    {
      name: "protocol_control_is_arbitration_i",
      desc: "Auto-extracted signal is_arbitration_i from protocol_control.vhd",
      swaccess: "rw",
      hwaccess: "hrw",
      fields: [
        {
          name: "value",
          bits: "31:0",
          desc: "Placeholder 32-bit field for extracted signal"
        }
      ]
    },
    {
      name: "protocol_control_bit_err_enable",
      desc: "Auto-extracted signal bit_err_enable from protocol_control.vhd",
      swaccess: "rw",
      hwaccess: "hrw",
      fields: [
        {
          name: "value",
          bits: "31:0",
          desc: "Placeholder 32-bit field for extracted signal"
        }
      ]
    },
    {
      name: "protocol_control_tx_data_nbs_i",
      desc: "Auto-extracted signal tx_data_nbs_i from protocol_control.vhd",
      swaccess: "rw",
      hwaccess: "hrw",
      fields: [
        {
          name: "value",
          bits: "31:0",
          desc: "Placeholder 32-bit field for extracted signal"
        }
      ]
    },
    {
      name: "protocol_control_rx_crc",
      desc: "Auto-extracted signal rx_crc from protocol_control.vhd",
      swaccess: "rw",
      hwaccess: "hrw",
      fields: [
        {
          name: "value",
          bits: "31:0",
          desc: "Placeholder 32-bit field for extracted signal"
        }
      ]
    },
    {
      name: "protocol_control_rx_stuff_count",
      desc: "Auto-extracted signal rx_stuff_count from protocol_control.vhd",
      swaccess: "rw",
      hwaccess: "hrw",
      fields: [
        {
          name: "value",
          bits: "31:0",
          desc: "Placeholder 32-bit field for extracted signal"
        }
      ]
    },
    {
      name: "protocol_control_fixed_stuff_i",
      desc: "Auto-extracted signal fixed_stuff_i from protocol_control.vhd",
      swaccess: "rw",
      hwaccess: "hrw",
      fields: [
        {
          name: "value",
          bits: "31:0",
          desc: "Placeholder 32-bit field for extracted signal"
        }
      ]
    },
    {
      name: "protocol_control_arbitration_lost_i",
      desc: "Auto-extracted signal arbitration_lost_i from protocol_control.vhd",
      swaccess: "rw",
      hwaccess: "hrw",
      fields: [
        {
          name: "value",
          bits: "31:0",
          desc: "Placeholder 32-bit field for extracted signal"
        }
      ]
    },
    {
      name: "protocol_control_alc_id_field",
      desc: "Auto-extracted signal alc_id_field from protocol_control.vhd",
      swaccess: "rw",
      hwaccess: "hrw",
      fields: [
        {
          name: "value",
          bits: "31:0",
          desc: "Placeholder 32-bit field for extracted signal"
        }
      ]
    },
    {
      name: "protocol_control_drv_rom_ena",
      desc: "Auto-extracted signal drv_rom_ena from protocol_control.vhd",
      swaccess: "rw",
      hwaccess: "hrw",
      fields: [
        {
          name: "value",
          bits: "31:0",
          desc: "Placeholder 32-bit field for extracted signal"
        }
      ]
    },
    {
      name: "protocol_control_fsm_state_reg_ce",
      desc: "Auto-extracted signal state_reg_ce from protocol_control_fsm.vhd",
      swaccess: "rw",
      hwaccess: "hrw",
      fields: [
        {
          name: "value",
          bits: "31:0",
          desc: "Placeholder 32-bit field for extracted signal"
        }
      ]
    },
    {
      name: "protocol_control_fsm_no_data_transmitter",
      desc: "Auto-extracted signal no_data_transmitter from protocol_control_fsm.vhd",
      swaccess: "rw",
      hwaccess: "hrw",
      fields: [
        {
          name: "value",
          bits: "31:0",
          desc: "Placeholder 32-bit field for extracted signal"
        }
      ]
    },
    {
      name: "protocol_control_fsm_no_data_receiver",
      desc: "Auto-extracted signal no_data_receiver from protocol_control_fsm.vhd",
      swaccess: "rw",
      hwaccess: "hrw",
      fields: [
        {
          name: "value",
          bits: "31:0",
          desc: "Placeholder 32-bit field for extracted signal"
        }
      ]
    },
    {
      name: "protocol_control_fsm_no_data_field",
      desc: "Auto-extracted signal no_data_field from protocol_control_fsm.vhd",
      swaccess: "rw",
      hwaccess: "hrw",
      fields: [
        {
          name: "value",
          bits: "31:0",
          desc: "Placeholder 32-bit field for extracted signal"
        }
      ]
    },
    {
      name: "protocol_control_fsm_ctrl_ctr_pload_i",
      desc: "Auto-extracted signal ctrl_ctr_pload_i from protocol_control_fsm.vhd",
      swaccess: "rw",
      hwaccess: "hrw",
      fields: [
        {
          name: "value",
          bits: "31:0",
          desc: "Placeholder 32-bit field for extracted signal"
        }
      ]
    },
    {
      name: "protocol_control_fsm_ctrl_ctr_pload_unaliged",
      desc: "Auto-extracted signal ctrl_ctr_pload_unaliged from protocol_control_fsm.vhd",
      swaccess: "rw",
      hwaccess: "hrw",
      fields: [
        {
          name: "value",
          bits: "31:0",
          desc: "Placeholder 32-bit field for extracted signal"
        }
      ]
    },
    {
      name: "protocol_control_fsm_crc_use_21",
      desc: "Auto-extracted signal crc_use_21 from protocol_control_fsm.vhd",
      swaccess: "rw",
      hwaccess: "hrw",
      fields: [
        {
          name: "value",
          bits: "31:0",
          desc: "Placeholder 32-bit field for extracted signal"
        }
      ]
    },
    {
      name: "protocol_control_fsm_crc_use_17",
      desc: "Auto-extracted signal crc_use_17 from protocol_control_fsm.vhd",
      swaccess: "rw",
      hwaccess: "hrw",
      fields: [
        {
          name: "value",
          bits: "31:0",
          desc: "Placeholder 32-bit field for extracted signal"
        }
      ]
    },
    {
      name: "protocol_control_fsm_crc_src_i",
      desc: "Auto-extracted signal crc_src_i from protocol_control_fsm.vhd",
      swaccess: "rw",
      hwaccess: "hrw",
      fields: [
        {
          name: "value",
          bits: "31:0",
          desc: "Placeholder 32-bit field for extracted signal"
        }
      ]
    },
    {
      name: "protocol_control_fsm_crc_length_i",
      desc: "Auto-extracted signal crc_length_i from protocol_control_fsm.vhd",
      swaccess: "rw",
      hwaccess: "hrw",
      fields: [
        {
          name: "value",
          bits: "31:0",
          desc: "Placeholder 32-bit field for extracted signal"
        }
      ]
    },
    {
      name: "protocol_control_fsm_tran_data_length",
      desc: "Auto-extracted signal tran_data_length from protocol_control_fsm.vhd",
      swaccess: "rw",
      hwaccess: "hrw",
      fields: [
        {
          name: "value",
          bits: "31:0",
          desc: "Placeholder 32-bit field for extracted signal"
        }
      ]
    },
    {
      name: "protocol_control_fsm_rec_data_length",
      desc: "Auto-extracted signal rec_data_length from protocol_control_fsm.vhd",
      swaccess: "rw",
      hwaccess: "hrw",
      fields: [
        {
          name: "value",
          bits: "31:0",
          desc: "Placeholder 32-bit field for extracted signal"
        }
      ]
    },
    {
      name: "protocol_control_fsm_rec_data_length_c",
      desc: "Auto-extracted signal rec_data_length_c from protocol_control_fsm.vhd",
      swaccess: "rw",
      hwaccess: "hrw",
      fields: [
        {
          name: "value",
          bits: "31:0",
          desc: "Placeholder 32-bit field for extracted signal"
        }
      ]
    },
    {
      name: "protocol_control_fsm_data_length_c",
      desc: "Auto-extracted signal data_length_c from protocol_control_fsm.vhd",
      swaccess: "rw",
      hwaccess: "hrw",
      fields: [
        {
          name: "value",
          bits: "31:0",
          desc: "Placeholder 32-bit field for extracted signal"
        }
      ]
    },
    {
      name: "protocol_control_fsm_data_length_shifted_c",
      desc: "Auto-extracted signal data_length_shifted_c from protocol_control_fsm.vhd",
      swaccess: "rw",
      hwaccess: "hrw",
      fields: [
        {
          name: "value",
          bits: "31:0",
          desc: "Placeholder 32-bit field for extracted signal"
        }
      ]
    },
    {
      name: "protocol_control_fsm_data_length_bits_c",
      desc: "Auto-extracted signal data_length_bits_c from protocol_control_fsm.vhd",
      swaccess: "rw",
      hwaccess: "hrw",
      fields: [
        {
          name: "value",
          bits: "31:0",
          desc: "Placeholder 32-bit field for extracted signal"
        }
      ]
    },
    {
      name: "protocol_control_fsm_is_fd_frame",
      desc: "Auto-extracted signal is_fd_frame from protocol_control_fsm.vhd",
      swaccess: "rw",
      hwaccess: "hrw",
      fields: [
        {
          name: "value",
          bits: "31:0",
          desc: "Placeholder 32-bit field for extracted signal"
        }
      ]
    },
    {
      name: "protocol_control_fsm_frame_start",
      desc: "Auto-extracted signal frame_start from protocol_control_fsm.vhd",
      swaccess: "rw",
      hwaccess: "hrw",
      fields: [
        {
          name: "value",
          bits: "31:0",
          desc: "Placeholder 32-bit field for extracted signal"
        }
      ]
    },
    {
      name: "protocol_control_fsm_tx_frame_ready",
      desc: "Auto-extracted signal tx_frame_ready from protocol_control_fsm.vhd",
      swaccess: "rw",
      hwaccess: "hrw",
      fields: [
        {
          name: "value",
          bits: "31:0",
          desc: "Placeholder 32-bit field for extracted signal"
        }
      ]
    },
    {
      name: "protocol_control_fsm_ide_is_arbitration",
      desc: "Auto-extracted signal ide_is_arbitration from protocol_control_fsm.vhd",
      swaccess: "rw",
      hwaccess: "hrw",
      fields: [
        {
          name: "value",
          bits: "31:0",
          desc: "Placeholder 32-bit field for extracted signal"
        }
      ]
    },
    {
      name: "protocol_control_fsm_arbitration_lost_condition",
      desc: "Auto-extracted signal arbitration_lost_condition from protocol_control_fsm.vhd",
      swaccess: "rw",
      hwaccess: "hrw",
      fields: [
        {
          name: "value",
          bits: "31:0",
          desc: "Placeholder 32-bit field for extracted signal"
        }
      ]
    },
    {
      name: "protocol_control_fsm_arbitration_lost_i",
      desc: "Auto-extracted signal arbitration_lost_i from protocol_control_fsm.vhd",
      swaccess: "rw",
      hwaccess: "hrw",
      fields: [
        {
          name: "value",
          bits: "31:0",
          desc: "Placeholder 32-bit field for extracted signal"
        }
      ]
    },
    {
      name: "protocol_control_fsm_tx_failed",
      desc: "Auto-extracted signal tx_failed from protocol_control_fsm.vhd",
      swaccess: "rw",
      hwaccess: "hrw",
      fields: [
        {
          name: "value",
          bits: "31:0",
          desc: "Placeholder 32-bit field for extracted signal"
        }
      ]
    },
    {
      name: "protocol_control_fsm_store_metadata_d",
      desc: "Auto-extracted signal store_metadata_d from protocol_control_fsm.vhd",
      swaccess: "rw",
      hwaccess: "hrw",
      fields: [
        {
          name: "value",
          bits: "31:0",
          desc: "Placeholder 32-bit field for extracted signal"
        }
      ]
    },
    {
      name: "protocol_control_fsm_store_data_d",
      desc: "Auto-extracted signal store_data_d from protocol_control_fsm.vhd",
      swaccess: "rw",
      hwaccess: "hrw",
      fields: [
        {
          name: "value",
          bits: "31:0",
          desc: "Placeholder 32-bit field for extracted signal"
        }
      ]
    },
    {
      name: "protocol_control_fsm_rec_valid_d",
      desc: "Auto-extracted signal rec_valid_d from protocol_control_fsm.vhd",
      swaccess: "rw",
      hwaccess: "hrw",
      fields: [
        {
          name: "value",
          bits: "31:0",
          desc: "Placeholder 32-bit field for extracted signal"
        }
      ]
    },
    {
      name: "protocol_control_fsm_rec_abort_d",
      desc: "Auto-extracted signal rec_abort_d from protocol_control_fsm.vhd",
      swaccess: "rw",
      hwaccess: "hrw",
      fields: [
        {
          name: "value",
          bits: "31:0",
          desc: "Placeholder 32-bit field for extracted signal"
        }
      ]
    },
    {
      name: "protocol_control_fsm_go_to_suspend",
      desc: "Auto-extracted signal go_to_suspend from protocol_control_fsm.vhd",
      swaccess: "rw",
      hwaccess: "hrw",
      fields: [
        {
          name: "value",
          bits: "31:0",
          desc: "Placeholder 32-bit field for extracted signal"
        }
      ]
    },
    {
      name: "protocol_control_fsm_go_to_stuff_count",
      desc: "Auto-extracted signal go_to_stuff_count from protocol_control_fsm.vhd",
      swaccess: "rw",
      hwaccess: "hrw",
      fields: [
        {
          name: "value",
          bits: "31:0",
          desc: "Placeholder 32-bit field for extracted signal"
        }
      ]
    },
    {
      name: "protocol_control_fsm_rx_store_base_id_i",
      desc: "Auto-extracted signal rx_store_base_id_i from protocol_control_fsm.vhd",
      swaccess: "rw",
      hwaccess: "hrw",
      fields: [
        {
          name: "value",
          bits: "31:0",
          desc: "Placeholder 32-bit field for extracted signal"
        }
      ]
    },
    {
      name: "protocol_control_fsm_rx_store_ext_id_i",
      desc: "Auto-extracted signal rx_store_ext_id_i from protocol_control_fsm.vhd",
      swaccess: "rw",
      hwaccess: "hrw",
      fields: [
        {
          name: "value",
          bits: "31:0",
          desc: "Placeholder 32-bit field for extracted signal"
        }
      ]
    },
    {
      name: "protocol_control_fsm_rx_store_ide_i",
      desc: "Auto-extracted signal rx_store_ide_i from protocol_control_fsm.vhd",
      swaccess: "rw",
      hwaccess: "hrw",
      fields: [
        {
          name: "value",
          bits: "31:0",
          desc: "Placeholder 32-bit field for extracted signal"
        }
      ]
    },
    {
      name: "protocol_control_fsm_rx_store_rtr_i",
      desc: "Auto-extracted signal rx_store_rtr_i from protocol_control_fsm.vhd",
      swaccess: "rw",
      hwaccess: "hrw",
      fields: [
        {
          name: "value",
          bits: "31:0",
          desc: "Placeholder 32-bit field for extracted signal"
        }
      ]
    },
    {
      name: "protocol_control_fsm_rx_store_edl_i",
      desc: "Auto-extracted signal rx_store_edl_i from protocol_control_fsm.vhd",
      swaccess: "rw",
      hwaccess: "hrw",
      fields: [
        {
          name: "value",
          bits: "31:0",
          desc: "Placeholder 32-bit field for extracted signal"
        }
      ]
    },
    {
      name: "protocol_control_fsm_rx_store_dlc_i",
      desc: "Auto-extracted signal rx_store_dlc_i from protocol_control_fsm.vhd",
      swaccess: "rw",
      hwaccess: "hrw",
      fields: [
        {
          name: "value",
          bits: "31:0",
          desc: "Placeholder 32-bit field for extracted signal"
        }
      ]
    },
    {
      name: "protocol_control_fsm_rx_store_esi_i",
      desc: "Auto-extracted signal rx_store_esi_i from protocol_control_fsm.vhd",
      swaccess: "rw",
      hwaccess: "hrw",
      fields: [
        {
          name: "value",
          bits: "31:0",
          desc: "Placeholder 32-bit field for extracted signal"
        }
      ]
    },
    {
      name: "protocol_control_fsm_rx_store_brs_i",
      desc: "Auto-extracted signal rx_store_brs_i from protocol_control_fsm.vhd",
      swaccess: "rw",
      hwaccess: "hrw",
      fields: [
        {
          name: "value",
          bits: "31:0",
          desc: "Placeholder 32-bit field for extracted signal"
        }
      ]
    },
    {
      name: "protocol_control_fsm_rx_store_stuff_count_i",
      desc: "Auto-extracted signal rx_store_stuff_count_i from protocol_control_fsm.vhd",
      swaccess: "rw",
      hwaccess: "hrw",
      fields: [
        {
          name: "value",
          bits: "31:0",
          desc: "Placeholder 32-bit field for extracted signal"
        }
      ]
    },
    {
      name: "protocol_control_fsm_rx_clear_i",
      desc: "Auto-extracted signal rx_clear_i from protocol_control_fsm.vhd",
      swaccess: "rw",
      hwaccess: "hrw",
      fields: [
        {
          name: "value",
          bits: "31:0",
          desc: "Placeholder 32-bit field for extracted signal"
        }
      ]
    },
    {
      name: "protocol_control_fsm_tx_load_base_id_i",
      desc: "Auto-extracted signal tx_load_base_id_i from protocol_control_fsm.vhd",
      swaccess: "rw",
      hwaccess: "hrw",
      fields: [
        {
          name: "value",
          bits: "31:0",
          desc: "Placeholder 32-bit field for extracted signal"
        }
      ]
    },
    {
      name: "protocol_control_fsm_tx_load_ext_id_i",
      desc: "Auto-extracted signal tx_load_ext_id_i from protocol_control_fsm.vhd",
      swaccess: "rw",
      hwaccess: "hrw",
      fields: [
        {
          name: "value",
          bits: "31:0",
          desc: "Placeholder 32-bit field for extracted signal"
        }
      ]
    },
    {
      name: "protocol_control_fsm_tx_load_dlc_i",
      desc: "Auto-extracted signal tx_load_dlc_i from protocol_control_fsm.vhd",
      swaccess: "rw",
      hwaccess: "hrw",
      fields: [
        {
          name: "value",
          bits: "31:0",
          desc: "Placeholder 32-bit field for extracted signal"
        }
      ]
    },
    {
      name: "protocol_control_fsm_tx_load_data_word_i",
      desc: "Auto-extracted signal tx_load_data_word_i from protocol_control_fsm.vhd",
      swaccess: "rw",
      hwaccess: "hrw",
      fields: [
        {
          name: "value",
          bits: "31:0",
          desc: "Placeholder 32-bit field for extracted signal"
        }
      ]
    },
    {
      name: "protocol_control_fsm_tx_load_stuff_count_i",
      desc: "Auto-extracted signal tx_load_stuff_count_i from protocol_control_fsm.vhd",
      swaccess: "rw",
      hwaccess: "hrw",
      fields: [
        {
          name: "value",
          bits: "31:0",
          desc: "Placeholder 32-bit field for extracted signal"
        }
      ]
    },
    {
      name: "protocol_control_fsm_tx_load_crc_i",
      desc: "Auto-extracted signal tx_load_crc_i from protocol_control_fsm.vhd",
      swaccess: "rw",
      hwaccess: "hrw",
      fields: [
        {
          name: "value",
          bits: "31:0",
          desc: "Placeholder 32-bit field for extracted signal"
        }
      ]
    },
    {
      name: "protocol_control_fsm_tx_shift_ena_i",
      desc: "Auto-extracted signal tx_shift_ena_i from protocol_control_fsm.vhd",
      swaccess: "rw",
      hwaccess: "hrw",
      fields: [
        {
          name: "value",
          bits: "31:0",
          desc: "Placeholder 32-bit field for extracted signal"
        }
      ]
    },
    {
      name: "protocol_control_fsm_form_err_i",
      desc: "Auto-extracted signal form_err_i from protocol_control_fsm.vhd",
      swaccess: "rw",
      hwaccess: "hrw",
      fields: [
        {
          name: "value",
          bits: "31:0",
          desc: "Placeholder 32-bit field for extracted signal"
        }
      ]
    },
    {
      name: "protocol_control_fsm_ack_err_i",
      desc: "Auto-extracted signal ack_err_i from protocol_control_fsm.vhd",
      swaccess: "rw",
      hwaccess: "hrw",
      fields: [
        {
          name: "value",
          bits: "31:0",
          desc: "Placeholder 32-bit field for extracted signal"
        }
      ]
    },
    {
      name: "protocol_control_fsm_ack_err_flag",
      desc: "Auto-extracted signal ack_err_flag from protocol_control_fsm.vhd",
      swaccess: "rw",
      hwaccess: "hrw",
      fields: [
        {
          name: "value",
          bits: "31:0",
          desc: "Placeholder 32-bit field for extracted signal"
        }
      ]
    },
    {
      name: "protocol_control_fsm_ack_err_flag_clr",
      desc: "Auto-extracted signal ack_err_flag_clr from protocol_control_fsm.vhd",
      swaccess: "rw",
      hwaccess: "hrw",
      fields: [
        {
          name: "value",
          bits: "31:0",
          desc: "Placeholder 32-bit field for extracted signal"
        }
      ]
    },
    {
      name: "protocol_control_fsm_crc_err_i",
      desc: "Auto-extracted signal crc_err_i from protocol_control_fsm.vhd",
      swaccess: "rw",
      hwaccess: "hrw",
      fields: [
        {
          name: "value",
          bits: "31:0",
          desc: "Placeholder 32-bit field for extracted signal"
        }
      ]
    },
    {
      name: "protocol_control_fsm_bit_err_arb_i",
      desc: "Auto-extracted signal bit_err_arb_i from protocol_control_fsm.vhd",
      swaccess: "rw",
      hwaccess: "hrw",
      fields: [
        {
          name: "value",
          bits: "31:0",
          desc: "Placeholder 32-bit field for extracted signal"
        }
      ]
    },
    {
      name: "protocol_control_fsm_sp_control_switch_data",
      desc: "Auto-extracted signal sp_control_switch_data from protocol_control_fsm.vhd",
      swaccess: "rw",
      hwaccess: "hrw",
      fields: [
        {
          name: "value",
          bits: "31:0",
          desc: "Placeholder 32-bit field for extracted signal"
        }
      ]
    },
    {
      name: "protocol_control_fsm_sp_control_switch_nominal",
      desc: "Auto-extracted signal sp_control_switch_nominal from protocol_control_fsm.vhd",
      swaccess: "rw",
      hwaccess: "hrw",
      fields: [
        {
          name: "value",
          bits: "31:0",
          desc: "Placeholder 32-bit field for extracted signal"
        }
      ]
    },
    {
      name: "protocol_control_fsm_switch_to_ssp",
      desc: "Auto-extracted signal switch_to_ssp from protocol_control_fsm.vhd",
      swaccess: "rw",
      hwaccess: "hrw",
      fields: [
        {
          name: "value",
          bits: "31:0",
          desc: "Placeholder 32-bit field for extracted signal"
        }
      ]
    },
    {
      name: "protocol_control_fsm_sp_control_ce",
      desc: "Auto-extracted signal sp_control_ce from protocol_control_fsm.vhd",
      swaccess: "rw",
      hwaccess: "hrw",
      fields: [
        {
          name: "value",
          bits: "31:0",
          desc: "Placeholder 32-bit field for extracted signal"
        }
      ]
    },
    {
      name: "protocol_control_fsm_sp_control_d",
      desc: "Auto-extracted signal sp_control_d from protocol_control_fsm.vhd",
      swaccess: "rw",
      hwaccess: "hrw",
      fields: [
        {
          name: "value",
          bits: "31:0",
          desc: "Placeholder 32-bit field for extracted signal"
        }
      ]
    },
    {
      name: "protocol_control_fsm_sp_control_q_i",
      desc: "Auto-extracted signal sp_control_q_i from protocol_control_fsm.vhd",
      swaccess: "rw",
      hwaccess: "hrw",
      fields: [
        {
          name: "value",
          bits: "31:0",
          desc: "Placeholder 32-bit field for extracted signal"
        }
      ]
    },
    {
      name: "protocol_control_fsm_ssp_reset_i",
      desc: "Auto-extracted signal ssp_reset_i from protocol_control_fsm.vhd",
      swaccess: "rw",
      hwaccess: "hrw",
      fields: [
        {
          name: "value",
          bits: "31:0",
          desc: "Placeholder 32-bit field for extracted signal"
        }
      ]
    },
    {
      name: "protocol_control_fsm_sync_control_d",
      desc: "Auto-extracted signal sync_control_d from protocol_control_fsm.vhd",
      swaccess: "rw",
      hwaccess: "hrw",
      fields: [
        {
          name: "value",
          bits: "31:0",
          desc: "Placeholder 32-bit field for extracted signal"
        }
      ]
    },
    {
      name: "protocol_control_fsm_sync_control_q",
      desc: "Auto-extracted signal sync_control_q from protocol_control_fsm.vhd",
      swaccess: "rw",
      hwaccess: "hrw",
      fields: [
        {
          name: "value",
          bits: "31:0",
          desc: "Placeholder 32-bit field for extracted signal"
        }
      ]
    },
    {
      name: "protocol_control_fsm_perform_hsync",
      desc: "Auto-extracted signal perform_hsync from protocol_control_fsm.vhd",
      swaccess: "rw",
      hwaccess: "hrw",
      fields: [
        {
          name: "value",
          bits: "31:0",
          desc: "Placeholder 32-bit field for extracted signal"
        }
      ]
    },
    {
      name: "protocol_control_fsm_primary_err_i",
      desc: "Auto-extracted signal primary_err_i from protocol_control_fsm.vhd",
      swaccess: "rw",
      hwaccess: "hrw",
      fields: [
        {
          name: "value",
          bits: "31:0",
          desc: "Placeholder 32-bit field for extracted signal"
        }
      ]
    },
    {
      name: "protocol_control_fsm_err_delim_late_i",
      desc: "Auto-extracted signal err_delim_late_i from protocol_control_fsm.vhd",
      swaccess: "rw",
      hwaccess: "hrw",
      fields: [
        {
          name: "value",
          bits: "31:0",
          desc: "Placeholder 32-bit field for extracted signal"
        }
      ]
    },
    {
      name: "protocol_control_fsm_set_err_active_i",
      desc: "Auto-extracted signal set_err_active_i from protocol_control_fsm.vhd",
      swaccess: "rw",
      hwaccess: "hrw",
      fields: [
        {
          name: "value",
          bits: "31:0",
          desc: "Placeholder 32-bit field for extracted signal"
        }
      ]
    },
    {
      name: "protocol_control_fsm_set_transmitter_i",
      desc: "Auto-extracted signal set_transmitter_i from protocol_control_fsm.vhd",
      swaccess: "rw",
      hwaccess: "hrw",
      fields: [
        {
          name: "value",
          bits: "31:0",
          desc: "Placeholder 32-bit field for extracted signal"
        }
      ]
    },
    {
      name: "protocol_control_fsm_set_receiver_i",
      desc: "Auto-extracted signal set_receiver_i from protocol_control_fsm.vhd",
      swaccess: "rw",
      hwaccess: "hrw",
      fields: [
        {
          name: "value",
          bits: "31:0",
          desc: "Placeholder 32-bit field for extracted signal"
        }
      ]
    },
    {
      name: "protocol_control_fsm_set_idle_i",
      desc: "Auto-extracted signal set_idle_i from protocol_control_fsm.vhd",
      swaccess: "rw",
      hwaccess: "hrw",
      fields: [
        {
          name: "value",
          bits: "31:0",
          desc: "Placeholder 32-bit field for extracted signal"
        }
      ]
    },
    {
      name: "protocol_control_fsm_first_err_delim_d",
      desc: "Auto-extracted signal first_err_delim_d from protocol_control_fsm.vhd",
      swaccess: "rw",
      hwaccess: "hrw",
      fields: [
        {
          name: "value",
          bits: "31:0",
          desc: "Placeholder 32-bit field for extracted signal"
        }
      ]
    },
    {
      name: "protocol_control_fsm_first_err_delim_q",
      desc: "Auto-extracted signal first_err_delim_q from protocol_control_fsm.vhd",
      swaccess: "rw",
      hwaccess: "hrw",
      fields: [
        {
          name: "value",
          bits: "31:0",
          desc: "Placeholder 32-bit field for extracted signal"
        }
      ]
    },
    {
      name: "protocol_control_fsm_stuff_enable_set",
      desc: "Auto-extracted signal stuff_enable_set from protocol_control_fsm.vhd",
      swaccess: "rw",
      hwaccess: "hrw",
      fields: [
        {
          name: "value",
          bits: "31:0",
          desc: "Placeholder 32-bit field for extracted signal"
        }
      ]
    },
    {
      name: "protocol_control_fsm_stuff_enable_clear",
      desc: "Auto-extracted signal stuff_enable_clear from protocol_control_fsm.vhd",
      swaccess: "rw",
      hwaccess: "hrw",
      fields: [
        {
          name: "value",
          bits: "31:0",
          desc: "Placeholder 32-bit field for extracted signal"
        }
      ]
    },
    {
      name: "protocol_control_fsm_destuff_enable_set",
      desc: "Auto-extracted signal destuff_enable_set from protocol_control_fsm.vhd",
      swaccess: "rw",
      hwaccess: "hrw",
      fields: [
        {
          name: "value",
          bits: "31:0",
          desc: "Placeholder 32-bit field for extracted signal"
        }
      ]
    },
    {
      name: "protocol_control_fsm_destuff_enable_clear",
      desc: "Auto-extracted signal destuff_enable_clear from protocol_control_fsm.vhd",
      swaccess: "rw",
      hwaccess: "hrw",
      fields: [
        {
          name: "value",
          bits: "31:0",
          desc: "Placeholder 32-bit field for extracted signal"
        }
      ]
    },
    {
      name: "protocol_control_fsm_bit_err_disable",
      desc: "Auto-extracted signal bit_err_disable from protocol_control_fsm.vhd",
      swaccess: "rw",
      hwaccess: "hrw",
      fields: [
        {
          name: "value",
          bits: "31:0",
          desc: "Placeholder 32-bit field for extracted signal"
        }
      ]
    },
    {
      name: "protocol_control_fsm_bit_err_disable_receiver",
      desc: "Auto-extracted signal bit_err_disable_receiver from protocol_control_fsm.vhd",
      swaccess: "rw",
      hwaccess: "hrw",
      fields: [
        {
          name: "value",
          bits: "31:0",
          desc: "Placeholder 32-bit field for extracted signal"
        }
      ]
    },
    {
      name: "protocol_control_fsm_sof_pulse_i",
      desc: "Auto-extracted signal sof_pulse_i from protocol_control_fsm.vhd",
      swaccess: "rw",
      hwaccess: "hrw",
      fields: [
        {
          name: "value",
          bits: "31:0",
          desc: "Placeholder 32-bit field for extracted signal"
        }
      ]
    },
    {
      name: "protocol_control_fsm_compl_ctr_ena_i",
      desc: "Auto-extracted signal compl_ctr_ena_i from protocol_control_fsm.vhd",
      swaccess: "rw",
      hwaccess: "hrw",
      fields: [
        {
          name: "value",
          bits: "31:0",
          desc: "Placeholder 32-bit field for extracted signal"
        }
      ]
    },
    {
      name: "protocol_control_fsm_tick_state_reg",
      desc: "Auto-extracted signal tick_state_reg from protocol_control_fsm.vhd",
      swaccess: "rw",
      hwaccess: "hrw",
      fields: [
        {
          name: "value",
          bits: "31:0",
          desc: "Placeholder 32-bit field for extracted signal"
        }
      ]
    },
    {
      name: "protocol_control_fsm_br_shifted_i",
      desc: "Auto-extracted signal br_shifted_i from protocol_control_fsm.vhd",
      swaccess: "rw",
      hwaccess: "hrw",
      fields: [
        {
          name: "value",
          bits: "31:0",
          desc: "Placeholder 32-bit field for extracted signal"
        }
      ]
    },
    {
      name: "protocol_control_fsm_is_arbitration_i",
      desc: "Auto-extracted signal is_arbitration_i from protocol_control_fsm.vhd",
      swaccess: "rw",
      hwaccess: "hrw",
      fields: [
        {
          name: "value",
          bits: "31:0",
          desc: "Placeholder 32-bit field for extracted signal"
        }
      ]
    },
    {
      name: "protocol_control_fsm_crc_spec_enable_i",
      desc: "Auto-extracted signal crc_spec_enable_i from protocol_control_fsm.vhd",
      swaccess: "rw",
      hwaccess: "hrw",
      fields: [
        {
          name: "value",
          bits: "31:0",
          desc: "Placeholder 32-bit field for extracted signal"
        }
      ]
    },
    {
      name: "protocol_control_fsm_load_init_vect_i",
      desc: "Auto-extracted signal load_init_vect_i from protocol_control_fsm.vhd",
      swaccess: "rw",
      hwaccess: "hrw",
      fields: [
        {
          name: "value",
          bits: "31:0",
          desc: "Placeholder 32-bit field for extracted signal"
        }
      ]
    },
    {
      name: "protocol_control_fsm_drv_bus_off_reset_q",
      desc: "Auto-extracted signal drv_bus_off_reset_q from protocol_control_fsm.vhd",
      swaccess: "rw",
      hwaccess: "hrw",
      fields: [
        {
          name: "value",
          bits: "31:0",
          desc: "Placeholder 32-bit field for extracted signal"
        }
      ]
    },
    {
      name: "protocol_control_fsm_retr_ctr_clear_i",
      desc: "Auto-extracted signal retr_ctr_clear_i from protocol_control_fsm.vhd",
      swaccess: "rw",
      hwaccess: "hrw",
      fields: [
        {
          name: "value",
          bits: "31:0",
          desc: "Placeholder 32-bit field for extracted signal"
        }
      ]
    },
    {
      name: "protocol_control_fsm_retr_ctr_add_i",
      desc: "Auto-extracted signal retr_ctr_add_i from protocol_control_fsm.vhd",
      swaccess: "rw",
      hwaccess: "hrw",
      fields: [
        {
          name: "value",
          bits: "31:0",
          desc: "Placeholder 32-bit field for extracted signal"
        }
      ]
    },
    {
      name: "protocol_control_fsm_decrement_rec_i",
      desc: "Auto-extracted signal decrement_rec_i from protocol_control_fsm.vhd",
      swaccess: "rw",
      hwaccess: "hrw",
      fields: [
        {
          name: "value",
          bits: "31:0",
          desc: "Placeholder 32-bit field for extracted signal"
        }
      ]
    },
    {
      name: "protocol_control_fsm_retr_ctr_add_block",
      desc: "Auto-extracted signal retr_ctr_add_block from protocol_control_fsm.vhd",
      swaccess: "rw",
      hwaccess: "hrw",
      fields: [
        {
          name: "value",
          bits: "31:0",
          desc: "Placeholder 32-bit field for extracted signal"
        }
      ]
    },
    {
      name: "protocol_control_fsm_retr_ctr_add_block_clr",
      desc: "Auto-extracted signal retr_ctr_add_block_clr from protocol_control_fsm.vhd",
      swaccess: "rw",
      hwaccess: "hrw",
      fields: [
        {
          name: "value",
          bits: "31:0",
          desc: "Placeholder 32-bit field for extracted signal"
        }
      ]
    },
    {
      name: "protocol_control_fsm_block_txtb_unlock",
      desc: "Auto-extracted signal block_txtb_unlock from protocol_control_fsm.vhd",
      swaccess: "rw",
      hwaccess: "hrw",
      fields: [
        {
          name: "value",
          bits: "31:0",
          desc: "Placeholder 32-bit field for extracted signal"
        }
      ]
    },
    {
      name: "protocol_control_fsm_tx_frame_no_sof_d",
      desc: "Auto-extracted signal tx_frame_no_sof_d from protocol_control_fsm.vhd",
      swaccess: "rw",
      hwaccess: "hrw",
      fields: [
        {
          name: "value",
          bits: "31:0",
          desc: "Placeholder 32-bit field for extracted signal"
        }
      ]
    },
    {
      name: "protocol_control_fsm_tx_frame_no_sof_q",
      desc: "Auto-extracted signal tx_frame_no_sof_q from protocol_control_fsm.vhd",
      swaccess: "rw",
      hwaccess: "hrw",
      fields: [
        {
          name: "value",
          bits: "31:0",
          desc: "Placeholder 32-bit field for extracted signal"
        }
      ]
    },
    {
      name: "protocol_control_fsm_ctrl_signal_upd",
      desc: "Auto-extracted signal ctrl_signal_upd from protocol_control_fsm.vhd",
      swaccess: "rw",
      hwaccess: "hrw",
      fields: [
        {
          name: "value",
          bits: "31:0",
          desc: "Placeholder 32-bit field for extracted signal"
        }
      ]
    },
    {
      name: "protocol_control_fsm_clr_bus_off_rst_flg",
      desc: "Auto-extracted signal clr_bus_off_rst_flg from protocol_control_fsm.vhd",
      swaccess: "rw",
      hwaccess: "hrw",
      fields: [
        {
          name: "value",
          bits: "31:0",
          desc: "Placeholder 32-bit field for extracted signal"
        }
      ]
    },
    {
      name: "protocol_control_fsm_pex_on_fdf_enable",
      desc: "Auto-extracted signal pex_on_fdf_enable from protocol_control_fsm.vhd",
      swaccess: "rw",
      hwaccess: "hrw",
      fields: [
        {
          name: "value",
          bits: "31:0",
          desc: "Placeholder 32-bit field for extracted signal"
        }
      ]
    },
    {
      name: "protocol_control_fsm_pex_on_res_enable",
      desc: "Auto-extracted signal pex_on_res_enable from protocol_control_fsm.vhd",
      swaccess: "rw",
      hwaccess: "hrw",
      fields: [
        {
          name: "value",
          bits: "31:0",
          desc: "Placeholder 32-bit field for extracted signal"
        }
      ]
    },
    {
      name: "protocol_control_fsm_rx_data_nbs_prev",
      desc: "Auto-extracted signal rx_data_nbs_prev from protocol_control_fsm.vhd",
      swaccess: "rw",
      hwaccess: "hrw",
      fields: [
        {
          name: "value",
          bits: "31:0",
          desc: "Placeholder 32-bit field for extracted signal"
        }
      ]
    },
    {
      name: "protocol_control_fsm_pexs_set",
      desc: "Auto-extracted signal pexs_set from protocol_control_fsm.vhd",
      swaccess: "rw",
      hwaccess: "hrw",
      fields: [
        {
          name: "value",
          bits: "31:0",
          desc: "Placeholder 32-bit field for extracted signal"
        }
      ]
    },
    {
      name: "protocol_control_fsm_tran_frame_type_i",
      desc: "Auto-extracted signal tran_frame_type_i from protocol_control_fsm.vhd",
      swaccess: "rw",
      hwaccess: "hrw",
      fields: [
        {
          name: "value",
          bits: "31:0",
          desc: "Placeholder 32-bit field for extracted signal"
        }
      ]
    },
    {
      name: "protocol_control_fsm_txtb_clk_en_d",
      desc: "Auto-extracted signal txtb_clk_en_d from protocol_control_fsm.vhd",
      swaccess: "rw",
      hwaccess: "hrw",
      fields: [
        {
          name: "value",
          bits: "31:0",
          desc: "Placeholder 32-bit field for extracted signal"
        }
      ]
    },
    {
      name: "protocol_control_fsm_txtb_clk_en_q",
      desc: "Auto-extracted signal txtb_clk_en_q from protocol_control_fsm.vhd",
      swaccess: "rw",
      hwaccess: "hrw",
      fields: [
        {
          name: "value",
          bits: "31:0",
          desc: "Placeholder 32-bit field for extracted signal"
        }
      ]
    },
    {
      name: "reintegration_counter_reinteg_ctr_ce",
      desc: "Auto-extracted signal reinteg_ctr_ce from reintegration_counter.vhd",
      swaccess: "rw",
      hwaccess: "hrw",
      fields: [
        {
          name: "value",
          bits: "31:0",
          desc: "Placeholder 32-bit field for extracted signal"
        }
      ]
    },
    {
      name: "retransmitt_counter_retr_ctr_ce",
      desc: "Auto-extracted signal retr_ctr_ce from retransmitt_counter.vhd",
      swaccess: "rw",
      hwaccess: "hrw",
      fields: [
        {
          name: "value",
          bits: "31:0",
          desc: "Placeholder 32-bit field for extracted signal"
        }
      ]
    },
    {
      name: "rst_sync_rff",
      desc: "Auto-extracted signal rff from rst_sync.vhd",
      swaccess: "rw",
      hwaccess: "hrw",
      fields: [
        {
          name: "value",
          bits: "31:0",
          desc: "Placeholder 32-bit field for extracted signal"
        }
      ]
    },
    {
      name: "rx_buffer_drv_erase_rx",
      desc: "Auto-extracted signal drv_erase_rx from rx_buffer.vhd",
      swaccess: "rw",
      hwaccess: "hrw",
      fields: [
        {
          name: "value",
          bits: "31:0",
          desc: "Placeholder 32-bit field for extracted signal"
        }
      ]
    },
    {
      name: "rx_buffer_drv_read_start",
      desc: "Auto-extracted signal drv_read_start from rx_buffer.vhd",
      swaccess: "rw",
      hwaccess: "hrw",
      fields: [
        {
          name: "value",
          bits: "31:0",
          desc: "Placeholder 32-bit field for extracted signal"
        }
      ]
    },
    {
      name: "rx_buffer_drv_clr_ovr",
      desc: "Auto-extracted signal drv_clr_ovr from rx_buffer.vhd",
      swaccess: "rw",
      hwaccess: "hrw",
      fields: [
        {
          name: "value",
          bits: "31:0",
          desc: "Placeholder 32-bit field for extracted signal"
        }
      ]
    },
    {
      name: "rx_buffer_drv_rtsopt",
      desc: "Auto-extracted signal drv_rtsopt from rx_buffer.vhd",
      swaccess: "rw",
      hwaccess: "hrw",
      fields: [
        {
          name: "value",
          bits: "31:0",
          desc: "Placeholder 32-bit field for extracted signal"
        }
      ]
    },
    {
      name: "rx_buffer_read_pointer",
      desc: "Auto-extracted signal read_pointer from rx_buffer.vhd",
      swaccess: "rw",
      hwaccess: "hrw",
      fields: [
        {
          name: "value",
          bits: "31:0",
          desc: "Placeholder 32-bit field for extracted signal"
        }
      ]
    },
    {
      name: "rx_buffer_read_pointer_inc_1",
      desc: "Auto-extracted signal read_pointer_inc_1 from rx_buffer.vhd",
      swaccess: "rw",
      hwaccess: "hrw",
      fields: [
        {
          name: "value",
          bits: "31:0",
          desc: "Placeholder 32-bit field for extracted signal"
        }
      ]
    },
    {
      name: "rx_buffer_write_pointer",
      desc: "Auto-extracted signal write_pointer from rx_buffer.vhd",
      swaccess: "rw",
      hwaccess: "hrw",
      fields: [
        {
          name: "value",
          bits: "31:0",
          desc: "Placeholder 32-bit field for extracted signal"
        }
      ]
    },
    {
      name: "rx_buffer_write_pointer_raw",
      desc: "Auto-extracted signal write_pointer_raw from rx_buffer.vhd",
      swaccess: "rw",
      hwaccess: "hrw",
      fields: [
        {
          name: "value",
          bits: "31:0",
          desc: "Placeholder 32-bit field for extracted signal"
        }
      ]
    },
    {
      name: "rx_buffer_write_pointer_ts",
      desc: "Auto-extracted signal write_pointer_ts from rx_buffer.vhd",
      swaccess: "rw",
      hwaccess: "hrw",
      fields: [
        {
          name: "value",
          bits: "31:0",
          desc: "Placeholder 32-bit field for extracted signal"
        }
      ]
    },
    {
      name: "rx_buffer_rx_mem_free_i",
      desc: "Auto-extracted signal rx_mem_free_i from rx_buffer.vhd",
      swaccess: "rw",
      hwaccess: "hrw",
      fields: [
        {
          name: "value",
          bits: "31:0",
          desc: "Placeholder 32-bit field for extracted signal"
        }
      ]
    },
    {
      name: "rx_buffer_memory_write_data",
      desc: "Auto-extracted signal memory_write_data from rx_buffer.vhd",
      swaccess: "rw",
      hwaccess: "hrw",
      fields: [
        {
          name: "value",
          bits: "31:0",
          desc: "Placeholder 32-bit field for extracted signal"
        }
      ]
    },
    {
      name: "rx_buffer_data_overrun_flg",
      desc: "Auto-extracted signal data_overrun_flg from rx_buffer.vhd",
      swaccess: "rw",
      hwaccess: "hrw",
      fields: [
        {
          name: "value",
          bits: "31:0",
          desc: "Placeholder 32-bit field for extracted signal"
        }
      ]
    },
    {
      name: "rx_buffer_data_overrun_i",
      desc: "Auto-extracted signal data_overrun_i from rx_buffer.vhd",
      swaccess: "rw",
      hwaccess: "hrw",
      fields: [
        {
          name: "value",
          bits: "31:0",
          desc: "Placeholder 32-bit field for extracted signal"
        }
      ]
    },
    {
      name: "rx_buffer_overrun_condition",
      desc: "Auto-extracted signal overrun_condition from rx_buffer.vhd",
      swaccess: "rw",
      hwaccess: "hrw",
      fields: [
        {
          name: "value",
          bits: "31:0",
          desc: "Placeholder 32-bit field for extracted signal"
        }
      ]
    },
    {
      name: "rx_buffer_rx_empty_i",
      desc: "Auto-extracted signal rx_empty_i from rx_buffer.vhd",
      swaccess: "rw",
      hwaccess: "hrw",
      fields: [
        {
          name: "value",
          bits: "31:0",
          desc: "Placeholder 32-bit field for extracted signal"
        }
      ]
    },
    {
      name: "rx_buffer_is_free_word",
      desc: "Auto-extracted signal is_free_word from rx_buffer.vhd",
      swaccess: "rw",
      hwaccess: "hrw",
      fields: [
        {
          name: "value",
          bits: "31:0",
          desc: "Placeholder 32-bit field for extracted signal"
        }
      ]
    },
    {
      name: "rx_buffer_commit_rx_frame",
      desc: "Auto-extracted signal commit_rx_frame from rx_buffer.vhd",
      swaccess: "rw",
      hwaccess: "hrw",
      fields: [
        {
          name: "value",
          bits: "31:0",
          desc: "Placeholder 32-bit field for extracted signal"
        }
      ]
    },
    {
      name: "rx_buffer_commit_overrun_abort",
      desc: "Auto-extracted signal commit_overrun_abort from rx_buffer.vhd",
      swaccess: "rw",
      hwaccess: "hrw",
      fields: [
        {
          name: "value",
          bits: "31:0",
          desc: "Placeholder 32-bit field for extracted signal"
        }
      ]
    },
    {
      name: "rx_buffer_read_increment",
      desc: "Auto-extracted signal read_increment from rx_buffer.vhd",
      swaccess: "rw",
      hwaccess: "hrw",
      fields: [
        {
          name: "value",
          bits: "31:0",
          desc: "Placeholder 32-bit field for extracted signal"
        }
      ]
    },
    {
      name: "rx_buffer_write_raw_OK",
      desc: "Auto-extracted signal write_raw_OK from rx_buffer.vhd",
      swaccess: "rw",
      hwaccess: "hrw",
      fields: [
        {
          name: "value",
          bits: "31:0",
          desc: "Placeholder 32-bit field for extracted signal"
        }
      ]
    },
    {
      name: "rx_buffer_write_raw_intent",
      desc: "Auto-extracted signal write_raw_intent from rx_buffer.vhd",
      swaccess: "rw",
      hwaccess: "hrw",
      fields: [
        {
          name: "value",
          bits: "31:0",
          desc: "Placeholder 32-bit field for extracted signal"
        }
      ]
    },
    {
      name: "rx_buffer_write_ts",
      desc: "Auto-extracted signal write_ts from rx_buffer.vhd",
      swaccess: "rw",
      hwaccess: "hrw",
      fields: [
        {
          name: "value",
          bits: "31:0",
          desc: "Placeholder 32-bit field for extracted signal"
        }
      ]
    },
    {
      name: "rx_buffer_stored_ts",
      desc: "Auto-extracted signal stored_ts from rx_buffer.vhd",
      swaccess: "rw",
      hwaccess: "hrw",
      fields: [
        {
          name: "value",
          bits: "31:0",
          desc: "Placeholder 32-bit field for extracted signal"
        }
      ]
    },
    {
      name: "rx_buffer_data_selector",
      desc: "Auto-extracted signal data_selector from rx_buffer.vhd",
      swaccess: "rw",
      hwaccess: "hrw",
      fields: [
        {
          name: "value",
          bits: "31:0",
          desc: "Placeholder 32-bit field for extracted signal"
        }
      ]
    },
    {
      name: "rx_buffer_store_ts_wr_ptr",
      desc: "Auto-extracted signal store_ts_wr_ptr from rx_buffer.vhd",
      swaccess: "rw",
      hwaccess: "hrw",
      fields: [
        {
          name: "value",
          bits: "31:0",
          desc: "Placeholder 32-bit field for extracted signal"
        }
      ]
    },
    {
      name: "rx_buffer_inc_ts_wr_ptr",
      desc: "Auto-extracted signal inc_ts_wr_ptr from rx_buffer.vhd",
      swaccess: "rw",
      hwaccess: "hrw",
      fields: [
        {
          name: "value",
          bits: "31:0",
          desc: "Placeholder 32-bit field for extracted signal"
        }
      ]
    },
    {
      name: "rx_buffer_reset_overrun_flag",
      desc: "Auto-extracted signal reset_overrun_flag from rx_buffer.vhd",
      swaccess: "rw",
      hwaccess: "hrw",
      fields: [
        {
          name: "value",
          bits: "31:0",
          desc: "Placeholder 32-bit field for extracted signal"
        }
      ]
    },
    {
      name: "rx_buffer_frame_form_w",
      desc: "Auto-extracted signal frame_form_w from rx_buffer.vhd",
      swaccess: "rw",
      hwaccess: "hrw",
      fields: [
        {
          name: "value",
          bits: "31:0",
          desc: "Placeholder 32-bit field for extracted signal"
        }
      ]
    },
    {
      name: "rx_buffer_timestamp_capture",
      desc: "Auto-extracted signal timestamp_capture from rx_buffer.vhd",
      swaccess: "rw",
      hwaccess: "hrw",
      fields: [
        {
          name: "value",
          bits: "31:0",
          desc: "Placeholder 32-bit field for extracted signal"
        }
      ]
    },
    {
      name: "rx_buffer_timestamp_capture_ce",
      desc: "Auto-extracted signal timestamp_capture_ce from rx_buffer.vhd",
      swaccess: "rw",
      hwaccess: "hrw",
      fields: [
        {
          name: "value",
          bits: "31:0",
          desc: "Placeholder 32-bit field for extracted signal"
        }
      ]
    },
    {
      name: "rx_buffer_RAM_write",
      desc: "Auto-extracted signal RAM_write from rx_buffer.vhd",
      swaccess: "rw",
      hwaccess: "hrw",
      fields: [
        {
          name: "value",
          bits: "31:0",
          desc: "Placeholder 32-bit field for extracted signal"
        }
      ]
    },
    {
      name: "rx_buffer_RAM_data_out",
      desc: "Auto-extracted signal RAM_data_out from rx_buffer.vhd",
      swaccess: "rw",
      hwaccess: "hrw",
      fields: [
        {
          name: "value",
          bits: "31:0",
          desc: "Placeholder 32-bit field for extracted signal"
        }
      ]
    },
    {
      name: "rx_buffer_RAM_write_address",
      desc: "Auto-extracted signal RAM_write_address from rx_buffer.vhd",
      swaccess: "rw",
      hwaccess: "hrw",
      fields: [
        {
          name: "value",
          bits: "31:0",
          desc: "Placeholder 32-bit field for extracted signal"
        }
      ]
    },
    {
      name: "rx_buffer_RAM_read_address",
      desc: "Auto-extracted signal RAM_read_address from rx_buffer.vhd",
      swaccess: "rw",
      hwaccess: "hrw",
      fields: [
        {
          name: "value",
          bits: "31:0",
          desc: "Placeholder 32-bit field for extracted signal"
        }
      ]
    },
    {
      name: "rx_buffer_rx_buf_res_n_d",
      desc: "Auto-extracted signal rx_buf_res_n_d from rx_buffer.vhd",
      swaccess: "rw",
      hwaccess: "hrw",
      fields: [
        {
          name: "value",
          bits: "31:0",
          desc: "Placeholder 32-bit field for extracted signal"
        }
      ]
    },
    {
      name: "rx_buffer_rx_buf_res_n_q",
      desc: "Auto-extracted signal rx_buf_res_n_q from rx_buffer.vhd",
      swaccess: "rw",
      hwaccess: "hrw",
      fields: [
        {
          name: "value",
          bits: "31:0",
          desc: "Placeholder 32-bit field for extracted signal"
        }
      ]
    },
    {
      name: "rx_buffer_rx_buf_res_n_q_scan",
      desc: "Auto-extracted signal rx_buf_res_n_q_scan from rx_buffer.vhd",
      swaccess: "rw",
      hwaccess: "hrw",
      fields: [
        {
          name: "value",
          bits: "31:0",
          desc: "Placeholder 32-bit field for extracted signal"
        }
      ]
    },
    {
      name: "rx_buffer_rx_buf_ram_clk_en",
      desc: "Auto-extracted signal rx_buf_ram_clk_en from rx_buffer.vhd",
      swaccess: "rw",
      hwaccess: "hrw",
      fields: [
        {
          name: "value",
          bits: "31:0",
          desc: "Placeholder 32-bit field for extracted signal"
        }
      ]
    },
    {
      name: "rx_buffer_clk_ram",
      desc: "Auto-extracted signal clk_ram from rx_buffer.vhd",
      swaccess: "rw",
      hwaccess: "hrw",
      fields: [
        {
          name: "value",
          bits: "31:0",
          desc: "Placeholder 32-bit field for extracted signal"
        }
      ]
    },
    {
      name: "rx_buffer_fsm_rx_fsm_ce",
      desc: "Auto-extracted signal rx_fsm_ce from rx_buffer_fsm.vhd",
      swaccess: "rw",
      hwaccess: "hrw",
      fields: [
        {
          name: "value",
          bits: "31:0",
          desc: "Placeholder 32-bit field for extracted signal"
        }
      ]
    },
    {
      name: "rx_buffer_fsm_cmd_join",
      desc: "Auto-extracted signal cmd_join from rx_buffer_fsm.vhd",
      swaccess: "rw",
      hwaccess: "hrw",
      fields: [
        {
          name: "value",
          bits: "31:0",
          desc: "Placeholder 32-bit field for extracted signal"
        }
      ]
    },
    {
      name: "rx_buffer_pointers_write_pointer_raw_ce",
      desc: "Auto-extracted signal write_pointer_raw_ce from rx_buffer_pointers.vhd",
      swaccess: "rw",
      hwaccess: "hrw",
      fields: [
        {
          name: "value",
          bits: "31:0",
          desc: "Placeholder 32-bit field for extracted signal"
        }
      ]
    },
    {
      name: "rx_buffer_pointers_write_pointer_ts_ce",
      desc: "Auto-extracted signal write_pointer_ts_ce from rx_buffer_pointers.vhd",
      swaccess: "rw",
      hwaccess: "hrw",
      fields: [
        {
          name: "value",
          bits: "31:0",
          desc: "Placeholder 32-bit field for extracted signal"
        }
      ]
    },
    {
      name: "rx_buffer_ram_port_a_address_i",
      desc: "Auto-extracted signal port_a_address_i from rx_buffer_ram.vhd",
      swaccess: "rw",
      hwaccess: "hrw",
      fields: [
        {
          name: "value",
          bits: "31:0",
          desc: "Placeholder 32-bit field for extracted signal"
        }
      ]
    },
    {
      name: "rx_buffer_ram_port_a_write_i",
      desc: "Auto-extracted signal port_a_write_i from rx_buffer_ram.vhd",
      swaccess: "rw",
      hwaccess: "hrw",
      fields: [
        {
          name: "value",
          bits: "31:0",
          desc: "Placeholder 32-bit field for extracted signal"
        }
      ]
    },
    {
      name: "rx_buffer_ram_port_a_data_in_i",
      desc: "Auto-extracted signal port_a_data_in_i from rx_buffer_ram.vhd",
      swaccess: "rw",
      hwaccess: "hrw",
      fields: [
        {
          name: "value",
          bits: "31:0",
          desc: "Placeholder 32-bit field for extracted signal"
        }
      ]
    },
    {
      name: "rx_buffer_ram_port_b_address_i",
      desc: "Auto-extracted signal port_b_address_i from rx_buffer_ram.vhd",
      swaccess: "rw",
      hwaccess: "hrw",
      fields: [
        {
          name: "value",
          bits: "31:0",
          desc: "Placeholder 32-bit field for extracted signal"
        }
      ]
    },
    {
      name: "rx_buffer_ram_port_b_data_out_i",
      desc: "Auto-extracted signal port_b_data_out_i from rx_buffer_ram.vhd",
      swaccess: "rw",
      hwaccess: "hrw",
      fields: [
        {
          name: "value",
          bits: "31:0",
          desc: "Placeholder 32-bit field for extracted signal"
        }
      ]
    },
    {
      name: "rx_buffer_ram_tst_ena",
      desc: "Auto-extracted signal tst_ena from rx_buffer_ram.vhd",
      swaccess: "rw",
      hwaccess: "hrw",
      fields: [
        {
          name: "value",
          bits: "31:0",
          desc: "Placeholder 32-bit field for extracted signal"
        }
      ]
    },
    {
      name: "rx_buffer_ram_tst_addr",
      desc: "Auto-extracted signal tst_addr from rx_buffer_ram.vhd",
      swaccess: "rw",
      hwaccess: "hrw",
      fields: [
        {
          name: "value",
          bits: "31:0",
          desc: "Placeholder 32-bit field for extracted signal"
        }
      ]
    },
    {
      name: "rx_shift_reg_res_n_i_d",
      desc: "Auto-extracted signal res_n_i_d from rx_shift_reg.vhd",
      swaccess: "rw",
      hwaccess: "hrw",
      fields: [
        {
          name: "value",
          bits: "31:0",
          desc: "Placeholder 32-bit field for extracted signal"
        }
      ]
    },
    {
      name: "rx_shift_reg_res_n_i_q",
      desc: "Auto-extracted signal res_n_i_q from rx_shift_reg.vhd",
      swaccess: "rw",
      hwaccess: "hrw",
      fields: [
        {
          name: "value",
          bits: "31:0",
          desc: "Placeholder 32-bit field for extracted signal"
        }
      ]
    },
    {
      name: "rx_shift_reg_res_n_i_q_scan",
      desc: "Auto-extracted signal res_n_i_q_scan from rx_shift_reg.vhd",
      swaccess: "rw",
      hwaccess: "hrw",
      fields: [
        {
          name: "value",
          bits: "31:0",
          desc: "Placeholder 32-bit field for extracted signal"
        }
      ]
    },
    {
      name: "rx_shift_reg_rx_shift_reg_q",
      desc: "Auto-extracted signal rx_shift_reg_q from rx_shift_reg.vhd",
      swaccess: "rw",
      hwaccess: "hrw",
      fields: [
        {
          name: "value",
          bits: "31:0",
          desc: "Placeholder 32-bit field for extracted signal"
        }
      ]
    },
    {
      name: "rx_shift_reg_rx_shift_cmd",
      desc: "Auto-extracted signal rx_shift_cmd from rx_shift_reg.vhd",
      swaccess: "rw",
      hwaccess: "hrw",
      fields: [
        {
          name: "value",
          bits: "31:0",
          desc: "Placeholder 32-bit field for extracted signal"
        }
      ]
    },
    {
      name: "rx_shift_reg_rx_shift_in_sel_demuxed",
      desc: "Auto-extracted signal rx_shift_in_sel_demuxed from rx_shift_reg.vhd",
      swaccess: "rw",
      hwaccess: "hrw",
      fields: [
        {
          name: "value",
          bits: "31:0",
          desc: "Placeholder 32-bit field for extracted signal"
        }
      ]
    },
    {
      name: "rx_shift_reg_rec_is_rtr_i",
      desc: "Auto-extracted signal rec_is_rtr_i from rx_shift_reg.vhd",
      swaccess: "rw",
      hwaccess: "hrw",
      fields: [
        {
          name: "value",
          bits: "31:0",
          desc: "Placeholder 32-bit field for extracted signal"
        }
      ]
    },
    {
      name: "rx_shift_reg_rec_frame_type_i",
      desc: "Auto-extracted signal rec_frame_type_i from rx_shift_reg.vhd",
      swaccess: "rw",
      hwaccess: "hrw",
      fields: [
        {
          name: "value",
          bits: "31:0",
          desc: "Placeholder 32-bit field for extracted signal"
        }
      ]
    },
    {
      name: "sample_mux_sample",
      desc: "Auto-extracted signal sample from sample_mux.vhd",
      swaccess: "rw",
      hwaccess: "hrw",
      fields: [
        {
          name: "value",
          bits: "31:0",
          desc: "Placeholder 32-bit field for extracted signal"
        }
      ]
    },
    {
      name: "sample_mux_prev_sample_d",
      desc: "Auto-extracted signal prev_sample_d from sample_mux.vhd",
      swaccess: "rw",
      hwaccess: "hrw",
      fields: [
        {
          name: "value",
          bits: "31:0",
          desc: "Placeholder 32-bit field for extracted signal"
        }
      ]
    },
    {
      name: "sample_mux_prev_sample_q",
      desc: "Auto-extracted signal prev_sample_q from sample_mux.vhd",
      swaccess: "rw",
      hwaccess: "hrw",
      fields: [
        {
          name: "value",
          bits: "31:0",
          desc: "Placeholder 32-bit field for extracted signal"
        }
      ]
    },
    {
      name: "segment_end_detector_req_input",
      desc: "Auto-extracted signal req_input from segment_end_detector.vhd",
      swaccess: "rw",
      hwaccess: "hrw",
      fields: [
        {
          name: "value",
          bits: "31:0",
          desc: "Placeholder 32-bit field for extracted signal"
        }
      ]
    },
    {
      name: "segment_end_detector_segm_end_req_capt_d",
      desc: "Auto-extracted signal segm_end_req_capt_d from segment_end_detector.vhd",
      swaccess: "rw",
      hwaccess: "hrw",
      fields: [
        {
          name: "value",
          bits: "31:0",
          desc: "Placeholder 32-bit field for extracted signal"
        }
      ]
    },
    {
      name: "segment_end_detector_segm_end_req_capt_q",
      desc: "Auto-extracted signal segm_end_req_capt_q from segment_end_detector.vhd",
      swaccess: "rw",
      hwaccess: "hrw",
      fields: [
        {
          name: "value",
          bits: "31:0",
          desc: "Placeholder 32-bit field for extracted signal"
        }
      ]
    },
    {
      name: "segment_end_detector_segm_end_req_capt_ce",
      desc: "Auto-extracted signal segm_end_req_capt_ce from segment_end_detector.vhd",
      swaccess: "rw",
      hwaccess: "hrw",
      fields: [
        {
          name: "value",
          bits: "31:0",
          desc: "Placeholder 32-bit field for extracted signal"
        }
      ]
    },
    {
      name: "segment_end_detector_segm_end_req_capt_clr",
      desc: "Auto-extracted signal segm_end_req_capt_clr from segment_end_detector.vhd",
      swaccess: "rw",
      hwaccess: "hrw",
      fields: [
        {
          name: "value",
          bits: "31:0",
          desc: "Placeholder 32-bit field for extracted signal"
        }
      ]
    },
    {
      name: "segment_end_detector_segm_end_req_capt_dq",
      desc: "Auto-extracted signal segm_end_req_capt_dq from segment_end_detector.vhd",
      swaccess: "rw",
      hwaccess: "hrw",
      fields: [
        {
          name: "value",
          bits: "31:0",
          desc: "Placeholder 32-bit field for extracted signal"
        }
      ]
    },
    {
      name: "segment_end_detector_segm_end_nbt_valid",
      desc: "Auto-extracted signal segm_end_nbt_valid from segment_end_detector.vhd",
      swaccess: "rw",
      hwaccess: "hrw",
      fields: [
        {
          name: "value",
          bits: "31:0",
          desc: "Placeholder 32-bit field for extracted signal"
        }
      ]
    },
    {
      name: "segment_end_detector_segm_end_dbt_valid",
      desc: "Auto-extracted signal segm_end_dbt_valid from segment_end_detector.vhd",
      swaccess: "rw",
      hwaccess: "hrw",
      fields: [
        {
          name: "value",
          bits: "31:0",
          desc: "Placeholder 32-bit field for extracted signal"
        }
      ]
    },
    {
      name: "segment_end_detector_segm_end_nbt_dbt_valid",
      desc: "Auto-extracted signal segm_end_nbt_dbt_valid from segment_end_detector.vhd",
      swaccess: "rw",
      hwaccess: "hrw",
      fields: [
        {
          name: "value",
          bits: "31:0",
          desc: "Placeholder 32-bit field for extracted signal"
        }
      ]
    },
    {
      name: "segment_end_detector_tseg1_end_req_valid",
      desc: "Auto-extracted signal tseg1_end_req_valid from segment_end_detector.vhd",
      swaccess: "rw",
      hwaccess: "hrw",
      fields: [
        {
          name: "value",
          bits: "31:0",
          desc: "Placeholder 32-bit field for extracted signal"
        }
      ]
    },
    {
      name: "segment_end_detector_tseg2_end_req_valid",
      desc: "Auto-extracted signal tseg2_end_req_valid from segment_end_detector.vhd",
      swaccess: "rw",
      hwaccess: "hrw",
      fields: [
        {
          name: "value",
          bits: "31:0",
          desc: "Placeholder 32-bit field for extracted signal"
        }
      ]
    },
    {
      name: "segment_end_detector_h_sync_valid_i",
      desc: "Auto-extracted signal h_sync_valid_i from segment_end_detector.vhd",
      swaccess: "rw",
      hwaccess: "hrw",
      fields: [
        {
          name: "value",
          bits: "31:0",
          desc: "Placeholder 32-bit field for extracted signal"
        }
      ]
    },
    {
      name: "segment_end_detector_segment_end_i",
      desc: "Auto-extracted signal segment_end_i from segment_end_detector.vhd",
      swaccess: "rw",
      hwaccess: "hrw",
      fields: [
        {
          name: "value",
          bits: "31:0",
          desc: "Placeholder 32-bit field for extracted signal"
        }
      ]
    },
    {
      name: "segment_end_detector_nbt_tq_active",
      desc: "Auto-extracted signal nbt_tq_active from segment_end_detector.vhd",
      swaccess: "rw",
      hwaccess: "hrw",
      fields: [
        {
          name: "value",
          bits: "31:0",
          desc: "Placeholder 32-bit field for extracted signal"
        }
      ]
    },
    {
      name: "segment_end_detector_dbt_tq_active",
      desc: "Auto-extracted signal dbt_tq_active from segment_end_detector.vhd",
      swaccess: "rw",
      hwaccess: "hrw",
      fields: [
        {
          name: "value",
          bits: "31:0",
          desc: "Placeholder 32-bit field for extracted signal"
        }
      ]
    },
    {
      name: "segment_end_detector_bt_ctr_clear_i",
      desc: "Auto-extracted signal bt_ctr_clear_i from segment_end_detector.vhd",
      swaccess: "rw",
      hwaccess: "hrw",
      fields: [
        {
          name: "value",
          bits: "31:0",
          desc: "Placeholder 32-bit field for extracted signal"
        }
      ]
    },
    {
      name: "shift_reg_shift_regs",
      desc: "Auto-extracted signal shift_regs from shift_reg.vhd",
      swaccess: "rw",
      hwaccess: "hrw",
      fields: [
        {
          name: "value",
          bits: "31:0",
          desc: "Placeholder 32-bit field for extracted signal"
        }
      ]
    },
    {
      name: "shift_reg_next_shift_reg_val",
      desc: "Auto-extracted signal next_shift_reg_val from shift_reg.vhd",
      swaccess: "rw",
      hwaccess: "hrw",
      fields: [
        {
          name: "value",
          bits: "31:0",
          desc: "Placeholder 32-bit field for extracted signal"
        }
      ]
    },
    {
      name: "shift_reg_byte_shift_reg_in",
      desc: "Auto-extracted signal shift_reg_in from shift_reg_byte.vhd",
      swaccess: "rw",
      hwaccess: "hrw",
      fields: [
        {
          name: "value",
          bits: "31:0",
          desc: "Placeholder 32-bit field for extracted signal"
        }
      ]
    },
    {
      name: "shift_reg_preload_shift_regs",
      desc: "Auto-extracted signal shift_regs from shift_reg_preload.vhd",
      swaccess: "rw",
      hwaccess: "hrw",
      fields: [
        {
          name: "value",
          bits: "31:0",
          desc: "Placeholder 32-bit field for extracted signal"
        }
      ]
    },
    {
      name: "shift_reg_preload_next_shift_reg_val",
      desc: "Auto-extracted signal next_shift_reg_val from shift_reg_preload.vhd",
      swaccess: "rw",
      hwaccess: "hrw",
      fields: [
        {
          name: "value",
          bits: "31:0",
          desc: "Placeholder 32-bit field for extracted signal"
        }
      ]
    },
    {
      name: "sig_sync_rff",
      desc: "Auto-extracted signal rff from sig_sync.vhd",
      swaccess: "rw",
      hwaccess: "hrw",
      fields: [
        {
          name: "value",
          bits: "31:0",
          desc: "Placeholder 32-bit field for extracted signal"
        }
      ]
    },
    {
      name: "ssp_generator_btmc_d",
      desc: "Auto-extracted signal btmc_d from ssp_generator.vhd",
      swaccess: "rw",
      hwaccess: "hrw",
      fields: [
        {
          name: "value",
          bits: "31:0",
          desc: "Placeholder 32-bit field for extracted signal"
        }
      ]
    },
    {
      name: "ssp_generator_btmc_q",
      desc: "Auto-extracted signal btmc_q from ssp_generator.vhd",
      swaccess: "rw",
      hwaccess: "hrw",
      fields: [
        {
          name: "value",
          bits: "31:0",
          desc: "Placeholder 32-bit field for extracted signal"
        }
      ]
    },
    {
      name: "ssp_generator_btmc_add",
      desc: "Auto-extracted signal btmc_add from ssp_generator.vhd",
      swaccess: "rw",
      hwaccess: "hrw",
      fields: [
        {
          name: "value",
          bits: "31:0",
          desc: "Placeholder 32-bit field for extracted signal"
        }
      ]
    },
    {
      name: "ssp_generator_btmc_ce",
      desc: "Auto-extracted signal btmc_ce from ssp_generator.vhd",
      swaccess: "rw",
      hwaccess: "hrw",
      fields: [
        {
          name: "value",
          bits: "31:0",
          desc: "Placeholder 32-bit field for extracted signal"
        }
      ]
    },
    {
      name: "ssp_generator_btmc_meas_running_d",
      desc: "Auto-extracted signal btmc_meas_running_d from ssp_generator.vhd",
      swaccess: "rw",
      hwaccess: "hrw",
      fields: [
        {
          name: "value",
          bits: "31:0",
          desc: "Placeholder 32-bit field for extracted signal"
        }
      ]
    },
    {
      name: "ssp_generator_btmc_meas_running_q",
      desc: "Auto-extracted signal btmc_meas_running_q from ssp_generator.vhd",
      swaccess: "rw",
      hwaccess: "hrw",
      fields: [
        {
          name: "value",
          bits: "31:0",
          desc: "Placeholder 32-bit field for extracted signal"
        }
      ]
    },
    {
      name: "ssp_generator_sspc_d",
      desc: "Auto-extracted signal sspc_d from ssp_generator.vhd",
      swaccess: "rw",
      hwaccess: "hrw",
      fields: [
        {
          name: "value",
          bits: "31:0",
          desc: "Placeholder 32-bit field for extracted signal"
        }
      ]
    },
    {
      name: "ssp_generator_sspc_q",
      desc: "Auto-extracted signal sspc_q from ssp_generator.vhd",
      swaccess: "rw",
      hwaccess: "hrw",
      fields: [
        {
          name: "value",
          bits: "31:0",
          desc: "Placeholder 32-bit field for extracted signal"
        }
      ]
    },
    {
      name: "ssp_generator_sspc_ce",
      desc: "Auto-extracted signal sspc_ce from ssp_generator.vhd",
      swaccess: "rw",
      hwaccess: "hrw",
      fields: [
        {
          name: "value",
          bits: "31:0",
          desc: "Placeholder 32-bit field for extracted signal"
        }
      ]
    },
    {
      name: "ssp_generator_sspc_expired",
      desc: "Auto-extracted signal sspc_expired from ssp_generator.vhd",
      swaccess: "rw",
      hwaccess: "hrw",
      fields: [
        {
          name: "value",
          bits: "31:0",
          desc: "Placeholder 32-bit field for extracted signal"
        }
      ]
    },
    {
      name: "ssp_generator_sspc_threshold",
      desc: "Auto-extracted signal sspc_threshold from ssp_generator.vhd",
      swaccess: "rw",
      hwaccess: "hrw",
      fields: [
        {
          name: "value",
          bits: "31:0",
          desc: "Placeholder 32-bit field for extracted signal"
        }
      ]
    },
    {
      name: "ssp_generator_sspc_add",
      desc: "Auto-extracted signal sspc_add from ssp_generator.vhd",
      swaccess: "rw",
      hwaccess: "hrw",
      fields: [
        {
          name: "value",
          bits: "31:0",
          desc: "Placeholder 32-bit field for extracted signal"
        }
      ]
    },
    {
      name: "ssp_generator_first_ssp_d",
      desc: "Auto-extracted signal first_ssp_d from ssp_generator.vhd",
      swaccess: "rw",
      hwaccess: "hrw",
      fields: [
        {
          name: "value",
          bits: "31:0",
          desc: "Placeholder 32-bit field for extracted signal"
        }
      ]
    },
    {
      name: "ssp_generator_first_ssp_q",
      desc: "Auto-extracted signal first_ssp_q from ssp_generator.vhd",
      swaccess: "rw",
      hwaccess: "hrw",
      fields: [
        {
          name: "value",
          bits: "31:0",
          desc: "Placeholder 32-bit field for extracted signal"
        }
      ]
    },
    {
      name: "ssp_generator_sspc_ena_d",
      desc: "Auto-extracted signal sspc_ena_d from ssp_generator.vhd",
      swaccess: "rw",
      hwaccess: "hrw",
      fields: [
        {
          name: "value",
          bits: "31:0",
          desc: "Placeholder 32-bit field for extracted signal"
        }
      ]
    },
    {
      name: "ssp_generator_sspc_ena_q",
      desc: "Auto-extracted signal sspc_ena_q from ssp_generator.vhd",
      swaccess: "rw",
      hwaccess: "hrw",
      fields: [
        {
          name: "value",
          bits: "31:0",
          desc: "Placeholder 32-bit field for extracted signal"
        }
      ]
    },
    {
      name: "ssp_generator_ssp_delay_padded",
      desc: "Auto-extracted signal ssp_delay_padded from ssp_generator.vhd",
      swaccess: "rw",
      hwaccess: "hrw",
      fields: [
        {
          name: "value",
          bits: "31:0",
          desc: "Placeholder 32-bit field for extracted signal"
        }
      ]
    },
    {
      name: "synchronisation_checker_resync_edge",
      desc: "Auto-extracted signal resync_edge from synchronisation_checker.vhd",
      swaccess: "rw",
      hwaccess: "hrw",
      fields: [
        {
          name: "value",
          bits: "31:0",
          desc: "Placeholder 32-bit field for extracted signal"
        }
      ]
    },
    {
      name: "synchronisation_checker_h_sync_edge",
      desc: "Auto-extracted signal h_sync_edge from synchronisation_checker.vhd",
      swaccess: "rw",
      hwaccess: "hrw",
      fields: [
        {
          name: "value",
          bits: "31:0",
          desc: "Placeholder 32-bit field for extracted signal"
        }
      ]
    },
    {
      name: "synchronisation_checker_h_or_re_sync_edge",
      desc: "Auto-extracted signal h_or_re_sync_edge from synchronisation_checker.vhd",
      swaccess: "rw",
      hwaccess: "hrw",
      fields: [
        {
          name: "value",
          bits: "31:0",
          desc: "Placeholder 32-bit field for extracted signal"
        }
      ]
    },
    {
      name: "synchronisation_checker_sync_flag",
      desc: "Auto-extracted signal sync_flag from synchronisation_checker.vhd",
      swaccess: "rw",
      hwaccess: "hrw",
      fields: [
        {
          name: "value",
          bits: "31:0",
          desc: "Placeholder 32-bit field for extracted signal"
        }
      ]
    },
    {
      name: "synchronisation_checker_sync_flag_ce",
      desc: "Auto-extracted signal sync_flag_ce from synchronisation_checker.vhd",
      swaccess: "rw",
      hwaccess: "hrw",
      fields: [
        {
          name: "value",
          bits: "31:0",
          desc: "Placeholder 32-bit field for extracted signal"
        }
      ]
    },
    {
      name: "synchronisation_checker_sync_flag_nxt",
      desc: "Auto-extracted signal sync_flag_nxt from synchronisation_checker.vhd",
      swaccess: "rw",
      hwaccess: "hrw",
      fields: [
        {
          name: "value",
          bits: "31:0",
          desc: "Placeholder 32-bit field for extracted signal"
        }
      ]
    },
    {
      name: "test_registers_reg_map_reg_sel",
      desc: "Auto-extracted signal reg_sel from test_registers_reg_map.vhd",
      swaccess: "rw",
      hwaccess: "hrw",
      fields: [
        {
          name: "value",
          bits: "31:0",
          desc: "Placeholder 32-bit field for extracted signal"
        }
      ]
    },
    {
      name: "test_registers_reg_map_read_data_mux_in",
      desc: "Auto-extracted signal read_data_mux_in from test_registers_reg_map.vhd",
      swaccess: "rw",
      hwaccess: "hrw",
      fields: [
        {
          name: "value",
          bits: "31:0",
          desc: "Placeholder 32-bit field for extracted signal"
        }
      ]
    },
    {
      name: "test_registers_reg_map_read_data_mask_n",
      desc: "Auto-extracted signal read_data_mask_n from test_registers_reg_map.vhd",
      swaccess: "rw",
      hwaccess: "hrw",
      fields: [
        {
          name: "value",
          bits: "31:0",
          desc: "Placeholder 32-bit field for extracted signal"
        }
      ]
    },
    {
      name: "test_registers_reg_map_read_mux_ena",
      desc: "Auto-extracted signal read_mux_ena from test_registers_reg_map.vhd",
      swaccess: "rw",
      hwaccess: "hrw",
      fields: [
        {
          name: "value",
          bits: "31:0",
          desc: "Placeholder 32-bit field for extracted signal"
        }
      ]
    },
    {
      name: "trigger_generator_rx_trig_req_q",
      desc: "Auto-extracted signal rx_trig_req_q from trigger_generator.vhd",
      swaccess: "rw",
      hwaccess: "hrw",
      fields: [
        {
          name: "value",
          bits: "31:0",
          desc: "Placeholder 32-bit field for extracted signal"
        }
      ]
    },
    {
      name: "trigger_generator_tx_trig_req_flag_d",
      desc: "Auto-extracted signal tx_trig_req_flag_d from trigger_generator.vhd",
      swaccess: "rw",
      hwaccess: "hrw",
      fields: [
        {
          name: "value",
          bits: "31:0",
          desc: "Placeholder 32-bit field for extracted signal"
        }
      ]
    },
    {
      name: "trigger_generator_tx_trig_req_flag_q",
      desc: "Auto-extracted signal tx_trig_req_flag_q from trigger_generator.vhd",
      swaccess: "rw",
      hwaccess: "hrw",
      fields: [
        {
          name: "value",
          bits: "31:0",
          desc: "Placeholder 32-bit field for extracted signal"
        }
      ]
    },
    {
      name: "trigger_generator_tx_trig_req_flag_dq",
      desc: "Auto-extracted signal tx_trig_req_flag_dq from trigger_generator.vhd",
      swaccess: "rw",
      hwaccess: "hrw",
      fields: [
        {
          name: "value",
          bits: "31:0",
          desc: "Placeholder 32-bit field for extracted signal"
        }
      ]
    },
    {
      name: "trigger_mux_tx_trigger_q",
      desc: "Auto-extracted signal tx_trigger_q from trigger_mux.vhd",
      swaccess: "rw",
      hwaccess: "hrw",
      fields: [
        {
          name: "value",
          bits: "31:0",
          desc: "Placeholder 32-bit field for extracted signal"
        }
      ]
    },
    {
      name: "trv_delay_meas_trv_meas_progress_d",
      desc: "Auto-extracted signal trv_meas_progress_d from trv_delay_meas.vhd",
      swaccess: "rw",
      hwaccess: "hrw",
      fields: [
        {
          name: "value",
          bits: "31:0",
          desc: "Placeholder 32-bit field for extracted signal"
        }
      ]
    },
    {
      name: "trv_delay_meas_trv_meas_progress_q",
      desc: "Auto-extracted signal trv_meas_progress_q from trv_delay_meas.vhd",
      swaccess: "rw",
      hwaccess: "hrw",
      fields: [
        {
          name: "value",
          bits: "31:0",
          desc: "Placeholder 32-bit field for extracted signal"
        }
      ]
    },
    {
      name: "trv_delay_meas_trv_meas_progress_del",
      desc: "Auto-extracted signal trv_meas_progress_del from trv_delay_meas.vhd",
      swaccess: "rw",
      hwaccess: "hrw",
      fields: [
        {
          name: "value",
          bits: "31:0",
          desc: "Placeholder 32-bit field for extracted signal"
        }
      ]
    },
    {
      name: "trv_delay_meas_trv_delay_ctr_q",
      desc: "Auto-extracted signal trv_delay_ctr_q from trv_delay_meas.vhd",
      swaccess: "rw",
      hwaccess: "hrw",
      fields: [
        {
          name: "value",
          bits: "31:0",
          desc: "Placeholder 32-bit field for extracted signal"
        }
      ]
    },
    {
      name: "trv_delay_meas_trv_delay_ctr_d",
      desc: "Auto-extracted signal trv_delay_ctr_d from trv_delay_meas.vhd",
      swaccess: "rw",
      hwaccess: "hrw",
      fields: [
        {
          name: "value",
          bits: "31:0",
          desc: "Placeholder 32-bit field for extracted signal"
        }
      ]
    },
    {
      name: "trv_delay_meas_trv_delay_ctr_add",
      desc: "Auto-extracted signal trv_delay_ctr_add from trv_delay_meas.vhd",
      swaccess: "rw",
      hwaccess: "hrw",
      fields: [
        {
          name: "value",
          bits: "31:0",
          desc: "Placeholder 32-bit field for extracted signal"
        }
      ]
    },
    {
      name: "trv_delay_meas_trv_delay_ctr_q_padded",
      desc: "Auto-extracted signal trv_delay_ctr_q_padded from trv_delay_meas.vhd",
      swaccess: "rw",
      hwaccess: "hrw",
      fields: [
        {
          name: "value",
          bits: "31:0",
          desc: "Placeholder 32-bit field for extracted signal"
        }
      ]
    },
    {
      name: "trv_delay_meas_trv_delay_ctr_rst_d",
      desc: "Auto-extracted signal trv_delay_ctr_rst_d from trv_delay_meas.vhd",
      swaccess: "rw",
      hwaccess: "hrw",
      fields: [
        {
          name: "value",
          bits: "31:0",
          desc: "Placeholder 32-bit field for extracted signal"
        }
      ]
    },
    {
      name: "trv_delay_meas_trv_delay_ctr_rst_q",
      desc: "Auto-extracted signal trv_delay_ctr_rst_q from trv_delay_meas.vhd",
      swaccess: "rw",
      hwaccess: "hrw",
      fields: [
        {
          name: "value",
          bits: "31:0",
          desc: "Placeholder 32-bit field for extracted signal"
        }
      ]
    },
    {
      name: "trv_delay_meas_trv_delay_ctr_rst_q_scan",
      desc: "Auto-extracted signal trv_delay_ctr_rst_q_scan from trv_delay_meas.vhd",
      swaccess: "rw",
      hwaccess: "hrw",
      fields: [
        {
          name: "value",
          bits: "31:0",
          desc: "Placeholder 32-bit field for extracted signal"
        }
      ]
    },
    {
      name: "trv_delay_meas_ssp_shadow_ce",
      desc: "Auto-extracted signal ssp_shadow_ce from trv_delay_meas.vhd",
      swaccess: "rw",
      hwaccess: "hrw",
      fields: [
        {
          name: "value",
          bits: "31:0",
          desc: "Placeholder 32-bit field for extracted signal"
        }
      ]
    },
    {
      name: "trv_delay_meas_ssp_delay_raw",
      desc: "Auto-extracted signal ssp_delay_raw from trv_delay_meas.vhd",
      swaccess: "rw",
      hwaccess: "hrw",
      fields: [
        {
          name: "value",
          bits: "31:0",
          desc: "Placeholder 32-bit field for extracted signal"
        }
      ]
    },
    {
      name: "trv_delay_meas_ssp_delay_saturated",
      desc: "Auto-extracted signal ssp_delay_saturated from trv_delay_meas.vhd",
      swaccess: "rw",
      hwaccess: "hrw",
      fields: [
        {
          name: "value",
          bits: "31:0",
          desc: "Placeholder 32-bit field for extracted signal"
        }
      ]
    },
    {
      name: "trv_delay_meas_trv_delay_sum",
      desc: "Auto-extracted signal trv_delay_sum from trv_delay_meas.vhd",
      swaccess: "rw",
      hwaccess: "hrw",
      fields: [
        {
          name: "value",
          bits: "31:0",
          desc: "Placeholder 32-bit field for extracted signal"
        }
      ]
    },
    {
      name: "tx_arbitrator_select_buf_avail",
      desc: "Auto-extracted signal select_buf_avail from tx_arbitrator.vhd",
      swaccess: "rw",
      hwaccess: "hrw",
      fields: [
        {
          name: "value",
          bits: "31:0",
          desc: "Placeholder 32-bit field for extracted signal"
        }
      ]
    },
    {
      name: "tx_arbitrator_txtb_selected_input",
      desc: "Auto-extracted signal txtb_selected_input from tx_arbitrator.vhd",
      swaccess: "rw",
      hwaccess: "hrw",
      fields: [
        {
          name: "value",
          bits: "31:0",
          desc: "Placeholder 32-bit field for extracted signal"
        }
      ]
    },
    {
      name: "tx_arbitrator_txtb_timestamp",
      desc: "Auto-extracted signal txtb_timestamp from tx_arbitrator.vhd",
      swaccess: "rw",
      hwaccess: "hrw",
      fields: [
        {
          name: "value",
          bits: "31:0",
          desc: "Placeholder 32-bit field for extracted signal"
        }
      ]
    },
    {
      name: "tx_arbitrator_timestamp_valid",
      desc: "Auto-extracted signal timestamp_valid from tx_arbitrator.vhd",
      swaccess: "rw",
      hwaccess: "hrw",
      fields: [
        {
          name: "value",
          bits: "31:0",
          desc: "Placeholder 32-bit field for extracted signal"
        }
      ]
    },
    {
      name: "tx_arbitrator_select_index_changed",
      desc: "Auto-extracted signal select_index_changed from tx_arbitrator.vhd",
      swaccess: "rw",
      hwaccess: "hrw",
      fields: [
        {
          name: "value",
          bits: "31:0",
          desc: "Placeholder 32-bit field for extracted signal"
        }
      ]
    },
    {
      name: "tx_arbitrator_validated_buffer",
      desc: "Auto-extracted signal validated_buffer from tx_arbitrator.vhd",
      swaccess: "rw",
      hwaccess: "hrw",
      fields: [
        {
          name: "value",
          bits: "31:0",
          desc: "Placeholder 32-bit field for extracted signal"
        }
      ]
    },
    {
      name: "tx_arbitrator_ts_low_internal",
      desc: "Auto-extracted signal ts_low_internal from tx_arbitrator.vhd",
      swaccess: "rw",
      hwaccess: "hrw",
      fields: [
        {
          name: "value",
          bits: "31:0",
          desc: "Placeholder 32-bit field for extracted signal"
        }
      ]
    },
    {
      name: "tx_arbitrator_tran_dlc_dbl_buf",
      desc: "Auto-extracted signal tran_dlc_dbl_buf from tx_arbitrator.vhd",
      swaccess: "rw",
      hwaccess: "hrw",
      fields: [
        {
          name: "value",
          bits: "31:0",
          desc: "Placeholder 32-bit field for extracted signal"
        }
      ]
    },
    {
      name: "tx_arbitrator_tran_is_rtr_dbl_buf",
      desc: "Auto-extracted signal tran_is_rtr_dbl_buf from tx_arbitrator.vhd",
      swaccess: "rw",
      hwaccess: "hrw",
      fields: [
        {
          name: "value",
          bits: "31:0",
          desc: "Placeholder 32-bit field for extracted signal"
        }
      ]
    },
    {
      name: "tx_arbitrator_tran_ident_type_dbl_buf",
      desc: "Auto-extracted signal tran_ident_type_dbl_buf from tx_arbitrator.vhd",
      swaccess: "rw",
      hwaccess: "hrw",
      fields: [
        {
          name: "value",
          bits: "31:0",
          desc: "Placeholder 32-bit field for extracted signal"
        }
      ]
    },
    {
      name: "tx_arbitrator_tran_frame_type_dbl_buf",
      desc: "Auto-extracted signal tran_frame_type_dbl_buf from tx_arbitrator.vhd",
      swaccess: "rw",
      hwaccess: "hrw",
      fields: [
        {
          name: "value",
          bits: "31:0",
          desc: "Placeholder 32-bit field for extracted signal"
        }
      ]
    },
    {
      name: "tx_arbitrator_tran_brs_dbl_buf",
      desc: "Auto-extracted signal tran_brs_dbl_buf from tx_arbitrator.vhd",
      swaccess: "rw",
      hwaccess: "hrw",
      fields: [
        {
          name: "value",
          bits: "31:0",
          desc: "Placeholder 32-bit field for extracted signal"
        }
      ]
    },
    {
      name: "tx_arbitrator_tran_dlc_com",
      desc: "Auto-extracted signal tran_dlc_com from tx_arbitrator.vhd",
      swaccess: "rw",
      hwaccess: "hrw",
      fields: [
        {
          name: "value",
          bits: "31:0",
          desc: "Placeholder 32-bit field for extracted signal"
        }
      ]
    },
    {
      name: "tx_arbitrator_tran_is_rtr_com",
      desc: "Auto-extracted signal tran_is_rtr_com from tx_arbitrator.vhd",
      swaccess: "rw",
      hwaccess: "hrw",
      fields: [
        {
          name: "value",
          bits: "31:0",
          desc: "Placeholder 32-bit field for extracted signal"
        }
      ]
    },
    {
      name: "tx_arbitrator_tran_ident_type_com",
      desc: "Auto-extracted signal tran_ident_type_com from tx_arbitrator.vhd",
      swaccess: "rw",
      hwaccess: "hrw",
      fields: [
        {
          name: "value",
          bits: "31:0",
          desc: "Placeholder 32-bit field for extracted signal"
        }
      ]
    },
    {
      name: "tx_arbitrator_tran_frame_type_com",
      desc: "Auto-extracted signal tran_frame_type_com from tx_arbitrator.vhd",
      swaccess: "rw",
      hwaccess: "hrw",
      fields: [
        {
          name: "value",
          bits: "31:0",
          desc: "Placeholder 32-bit field for extracted signal"
        }
      ]
    },
    {
      name: "tx_arbitrator_tran_brs_com",
      desc: "Auto-extracted signal tran_brs_com from tx_arbitrator.vhd",
      swaccess: "rw",
      hwaccess: "hrw",
      fields: [
        {
          name: "value",
          bits: "31:0",
          desc: "Placeholder 32-bit field for extracted signal"
        }
      ]
    },
    {
      name: "tx_arbitrator_tran_frame_valid_com",
      desc: "Auto-extracted signal tran_frame_valid_com from tx_arbitrator.vhd",
      swaccess: "rw",
      hwaccess: "hrw",
      fields: [
        {
          name: "value",
          bits: "31:0",
          desc: "Placeholder 32-bit field for extracted signal"
        }
      ]
    },
    {
      name: "tx_arbitrator_tran_identifier_com",
      desc: "Auto-extracted signal tran_identifier_com from tx_arbitrator.vhd",
      swaccess: "rw",
      hwaccess: "hrw",
      fields: [
        {
          name: "value",
          bits: "31:0",
          desc: "Placeholder 32-bit field for extracted signal"
        }
      ]
    },
    {
      name: "tx_arbitrator_load_ts_lw_addr",
      desc: "Auto-extracted signal load_ts_lw_addr from tx_arbitrator.vhd",
      swaccess: "rw",
      hwaccess: "hrw",
      fields: [
        {
          name: "value",
          bits: "31:0",
          desc: "Placeholder 32-bit field for extracted signal"
        }
      ]
    },
    {
      name: "tx_arbitrator_load_ts_uw_addr",
      desc: "Auto-extracted signal load_ts_uw_addr from tx_arbitrator.vhd",
      swaccess: "rw",
      hwaccess: "hrw",
      fields: [
        {
          name: "value",
          bits: "31:0",
          desc: "Placeholder 32-bit field for extracted signal"
        }
      ]
    },
    {
      name: "tx_arbitrator_load_ffmt_w_addr",
      desc: "Auto-extracted signal load_ffmt_w_addr from tx_arbitrator.vhd",
      swaccess: "rw",
      hwaccess: "hrw",
      fields: [
        {
          name: "value",
          bits: "31:0",
          desc: "Placeholder 32-bit field for extracted signal"
        }
      ]
    },
    {
      name: "tx_arbitrator_load_ident_w_addr",
      desc: "Auto-extracted signal load_ident_w_addr from tx_arbitrator.vhd",
      swaccess: "rw",
      hwaccess: "hrw",
      fields: [
        {
          name: "value",
          bits: "31:0",
          desc: "Placeholder 32-bit field for extracted signal"
        }
      ]
    },
    {
      name: "tx_arbitrator_store_ts_l_w",
      desc: "Auto-extracted signal store_ts_l_w from tx_arbitrator.vhd",
      swaccess: "rw",
      hwaccess: "hrw",
      fields: [
        {
          name: "value",
          bits: "31:0",
          desc: "Placeholder 32-bit field for extracted signal"
        }
      ]
    },
    {
      name: "tx_arbitrator_store_md_w",
      desc: "Auto-extracted signal store_md_w from tx_arbitrator.vhd",
      swaccess: "rw",
      hwaccess: "hrw",
      fields: [
        {
          name: "value",
          bits: "31:0",
          desc: "Placeholder 32-bit field for extracted signal"
        }
      ]
    },
    {
      name: "tx_arbitrator_store_ident_w",
      desc: "Auto-extracted signal store_ident_w from tx_arbitrator.vhd",
      swaccess: "rw",
      hwaccess: "hrw",
      fields: [
        {
          name: "value",
          bits: "31:0",
          desc: "Placeholder 32-bit field for extracted signal"
        }
      ]
    },
    {
      name: "tx_arbitrator_buffer_md_w",
      desc: "Auto-extracted signal buffer_md_w from tx_arbitrator.vhd",
      swaccess: "rw",
      hwaccess: "hrw",
      fields: [
        {
          name: "value",
          bits: "31:0",
          desc: "Placeholder 32-bit field for extracted signal"
        }
      ]
    },
    {
      name: "tx_arbitrator_store_last_txtb_index",
      desc: "Auto-extracted signal store_last_txtb_index from tx_arbitrator.vhd",
      swaccess: "rw",
      hwaccess: "hrw",
      fields: [
        {
          name: "value",
          bits: "31:0",
          desc: "Placeholder 32-bit field for extracted signal"
        }
      ]
    },
    {
      name: "tx_arbitrator_frame_valid_com_set",
      desc: "Auto-extracted signal frame_valid_com_set from tx_arbitrator.vhd",
      swaccess: "rw",
      hwaccess: "hrw",
      fields: [
        {
          name: "value",
          bits: "31:0",
          desc: "Placeholder 32-bit field for extracted signal"
        }
      ]
    },
    {
      name: "tx_arbitrator_frame_valid_com_clear",
      desc: "Auto-extracted signal frame_valid_com_clear from tx_arbitrator.vhd",
      swaccess: "rw",
      hwaccess: "hrw",
      fields: [
        {
          name: "value",
          bits: "31:0",
          desc: "Placeholder 32-bit field for extracted signal"
        }
      ]
    },
    {
      name: "tx_arbitrator_tx_arb_locked",
      desc: "Auto-extracted signal tx_arb_locked from tx_arbitrator.vhd",
      swaccess: "rw",
      hwaccess: "hrw",
      fields: [
        {
          name: "value",
          bits: "31:0",
          desc: "Placeholder 32-bit field for extracted signal"
        }
      ]
    },
    {
      name: "tx_arbitrator_txtb_meta_clk_en",
      desc: "Auto-extracted signal txtb_meta_clk_en from tx_arbitrator.vhd",
      swaccess: "rw",
      hwaccess: "hrw",
      fields: [
        {
          name: "value",
          bits: "31:0",
          desc: "Placeholder 32-bit field for extracted signal"
        }
      ]
    },
    {
      name: "tx_arbitrator_drv_tttm_ena",
      desc: "Auto-extracted signal drv_tttm_ena from tx_arbitrator.vhd",
      swaccess: "rw",
      hwaccess: "hrw",
      fields: [
        {
          name: "value",
          bits: "31:0",
          desc: "Placeholder 32-bit field for extracted signal"
        }
      ]
    },
    {
      name: "tx_arbitrator_fsm_tx_arb_fsm_ce",
      desc: "Auto-extracted signal tx_arb_fsm_ce from tx_arbitrator_fsm.vhd",
      swaccess: "rw",
      hwaccess: "hrw",
      fields: [
        {
          name: "value",
          bits: "31:0",
          desc: "Placeholder 32-bit field for extracted signal"
        }
      ]
    },
    {
      name: "tx_arbitrator_fsm_fsm_wait_state_d",
      desc: "Auto-extracted signal fsm_wait_state_d from tx_arbitrator_fsm.vhd",
      swaccess: "rw",
      hwaccess: "hrw",
      fields: [
        {
          name: "value",
          bits: "31:0",
          desc: "Placeholder 32-bit field for extracted signal"
        }
      ]
    },
    {
      name: "tx_arbitrator_fsm_fsm_wait_state_q",
      desc: "Auto-extracted signal fsm_wait_state_q from tx_arbitrator_fsm.vhd",
      swaccess: "rw",
      hwaccess: "hrw",
      fields: [
        {
          name: "value",
          bits: "31:0",
          desc: "Placeholder 32-bit field for extracted signal"
        }
      ]
    },
    {
      name: "tx_data_cache_tx_cache_mem",
      desc: "Auto-extracted signal tx_cache_mem from tx_data_cache.vhd",
      swaccess: "rw",
      hwaccess: "hrw",
      fields: [
        {
          name: "value",
          bits: "31:0",
          desc: "Placeholder 32-bit field for extracted signal"
        }
      ]
    },
    {
      name: "tx_shift_reg_tx_sr_output",
      desc: "Auto-extracted signal tx_sr_output from tx_shift_reg.vhd",
      swaccess: "rw",
      hwaccess: "hrw",
      fields: [
        {
          name: "value",
          bits: "31:0",
          desc: "Placeholder 32-bit field for extracted signal"
        }
      ]
    },
    {
      name: "tx_shift_reg_tx_sr_ce",
      desc: "Auto-extracted signal tx_sr_ce from tx_shift_reg.vhd",
      swaccess: "rw",
      hwaccess: "hrw",
      fields: [
        {
          name: "value",
          bits: "31:0",
          desc: "Placeholder 32-bit field for extracted signal"
        }
      ]
    },
    {
      name: "tx_shift_reg_tx_sr_pload",
      desc: "Auto-extracted signal tx_sr_pload from tx_shift_reg.vhd",
      swaccess: "rw",
      hwaccess: "hrw",
      fields: [
        {
          name: "value",
          bits: "31:0",
          desc: "Placeholder 32-bit field for extracted signal"
        }
      ]
    },
    {
      name: "tx_shift_reg_tx_sr_pload_val",
      desc: "Auto-extracted signal tx_sr_pload_val from tx_shift_reg.vhd",
      swaccess: "rw",
      hwaccess: "hrw",
      fields: [
        {
          name: "value",
          bits: "31:0",
          desc: "Placeholder 32-bit field for extracted signal"
        }
      ]
    },
    {
      name: "tx_shift_reg_tx_base_id",
      desc: "Auto-extracted signal tx_base_id from tx_shift_reg.vhd",
      swaccess: "rw",
      hwaccess: "hrw",
      fields: [
        {
          name: "value",
          bits: "31:0",
          desc: "Placeholder 32-bit field for extracted signal"
        }
      ]
    },
    {
      name: "tx_shift_reg_tx_ext_id",
      desc: "Auto-extracted signal tx_ext_id from tx_shift_reg.vhd",
      swaccess: "rw",
      hwaccess: "hrw",
      fields: [
        {
          name: "value",
          bits: "31:0",
          desc: "Placeholder 32-bit field for extracted signal"
        }
      ]
    },
    {
      name: "tx_shift_reg_tx_crc",
      desc: "Auto-extracted signal tx_crc from tx_shift_reg.vhd",
      swaccess: "rw",
      hwaccess: "hrw",
      fields: [
        {
          name: "value",
          bits: "31:0",
          desc: "Placeholder 32-bit field for extracted signal"
        }
      ]
    },
    {
      name: "tx_shift_reg_bst_ctr_grey",
      desc: "Auto-extracted signal bst_ctr_grey from tx_shift_reg.vhd",
      swaccess: "rw",
      hwaccess: "hrw",
      fields: [
        {
          name: "value",
          bits: "31:0",
          desc: "Placeholder 32-bit field for extracted signal"
        }
      ]
    },
    {
      name: "tx_shift_reg_bst_parity",
      desc: "Auto-extracted signal bst_parity from tx_shift_reg.vhd",
      swaccess: "rw",
      hwaccess: "hrw",
      fields: [
        {
          name: "value",
          bits: "31:0",
          desc: "Placeholder 32-bit field for extracted signal"
        }
      ]
    },
    {
      name: "tx_shift_reg_stuff_count",
      desc: "Auto-extracted signal stuff_count from tx_shift_reg.vhd",
      swaccess: "rw",
      hwaccess: "hrw",
      fields: [
        {
          name: "value",
          bits: "31:0",
          desc: "Placeholder 32-bit field for extracted signal"
        }
      ]
    },
    {
      name: "txt_buffer_txtb_user_accessible",
      desc: "Auto-extracted signal txtb_user_accessible from txt_buffer.vhd",
      swaccess: "rw",
      hwaccess: "hrw",
      fields: [
        {
          name: "value",
          bits: "31:0",
          desc: "Placeholder 32-bit field for extracted signal"
        }
      ]
    },
    {
      name: "txt_buffer_hw_cbs",
      desc: "Auto-extracted signal hw_cbs from txt_buffer.vhd",
      swaccess: "rw",
      hwaccess: "hrw",
      fields: [
        {
          name: "value",
          bits: "31:0",
          desc: "Placeholder 32-bit field for extracted signal"
        }
      ]
    },
    {
      name: "txt_buffer_sw_cbs",
      desc: "Auto-extracted signal sw_cbs from txt_buffer.vhd",
      swaccess: "rw",
      hwaccess: "hrw",
      fields: [
        {
          name: "value",
          bits: "31:0",
          desc: "Placeholder 32-bit field for extracted signal"
        }
      ]
    },
    {
      name: "txt_buffer_txtb_unmask_data_ram",
      desc: "Auto-extracted signal txtb_unmask_data_ram from txt_buffer.vhd",
      swaccess: "rw",
      hwaccess: "hrw",
      fields: [
        {
          name: "value",
          bits: "31:0",
          desc: "Placeholder 32-bit field for extracted signal"
        }
      ]
    },
    {
      name: "txt_buffer_txtb_port_b_data_i",
      desc: "Auto-extracted signal txtb_port_b_data_i from txt_buffer.vhd",
      swaccess: "rw",
      hwaccess: "hrw",
      fields: [
        {
          name: "value",
          bits: "31:0",
          desc: "Placeholder 32-bit field for extracted signal"
        }
      ]
    },
    {
      name: "txt_buffer_ram_write",
      desc: "Auto-extracted signal ram_write from txt_buffer.vhd",
      swaccess: "rw",
      hwaccess: "hrw",
      fields: [
        {
          name: "value",
          bits: "31:0",
          desc: "Placeholder 32-bit field for extracted signal"
        }
      ]
    },
    {
      name: "txt_buffer_ram_read_address",
      desc: "Auto-extracted signal ram_read_address from txt_buffer.vhd",
      swaccess: "rw",
      hwaccess: "hrw",
      fields: [
        {
          name: "value",
          bits: "31:0",
          desc: "Placeholder 32-bit field for extracted signal"
        }
      ]
    },
    {
      name: "txt_buffer_txtb_ram_clk_en",
      desc: "Auto-extracted signal txtb_ram_clk_en from txt_buffer.vhd",
      swaccess: "rw",
      hwaccess: "hrw",
      fields: [
        {
          name: "value",
          bits: "31:0",
          desc: "Placeholder 32-bit field for extracted signal"
        }
      ]
    },
    {
      name: "txt_buffer_clk_ram",
      desc: "Auto-extracted signal clk_ram from txt_buffer.vhd",
      swaccess: "rw",
      hwaccess: "hrw",
      fields: [
        {
          name: "value",
          bits: "31:0",
          desc: "Placeholder 32-bit field for extracted signal"
        }
      ]
    },
    {
      name: "txt_buffer_fsm_abort_applied",
      desc: "Auto-extracted signal abort_applied from txt_buffer_fsm.vhd",
      swaccess: "rw",
      hwaccess: "hrw",
      fields: [
        {
          name: "value",
          bits: "31:0",
          desc: "Placeholder 32-bit field for extracted signal"
        }
      ]
    },
    {
      name: "txt_buffer_fsm_txt_fsm_ce",
      desc: "Auto-extracted signal txt_fsm_ce from txt_buffer_fsm.vhd",
      swaccess: "rw",
      hwaccess: "hrw",
      fields: [
        {
          name: "value",
          bits: "31:0",
          desc: "Placeholder 32-bit field for extracted signal"
        }
      ]
    },
    {
      name: "txt_buffer_fsm_go_to_failed",
      desc: "Auto-extracted signal go_to_failed from txt_buffer_fsm.vhd",
      swaccess: "rw",
      hwaccess: "hrw",
      fields: [
        {
          name: "value",
          bits: "31:0",
          desc: "Placeholder 32-bit field for extracted signal"
        }
      ]
    },
    {
      name: "txt_buffer_fsm_transient_state",
      desc: "Auto-extracted signal transient_state from txt_buffer_fsm.vhd",
      swaccess: "rw",
      hwaccess: "hrw",
      fields: [
        {
          name: "value",
          bits: "31:0",
          desc: "Placeholder 32-bit field for extracted signal"
        }
      ]
    },
    {
      name: "txt_buffer_ram_port_a_address_i",
      desc: "Auto-extracted signal port_a_address_i from txt_buffer_ram.vhd",
      swaccess: "rw",
      hwaccess: "hrw",
      fields: [
        {
          name: "value",
          bits: "31:0",
          desc: "Placeholder 32-bit field for extracted signal"
        }
      ]
    },
    {
      name: "txt_buffer_ram_port_a_write_i",
      desc: "Auto-extracted signal port_a_write_i from txt_buffer_ram.vhd",
      swaccess: "rw",
      hwaccess: "hrw",
      fields: [
        {
          name: "value",
          bits: "31:0",
          desc: "Placeholder 32-bit field for extracted signal"
        }
      ]
    },
    {
      name: "txt_buffer_ram_port_a_data_in_i",
      desc: "Auto-extracted signal port_a_data_in_i from txt_buffer_ram.vhd",
      swaccess: "rw",
      hwaccess: "hrw",
      fields: [
        {
          name: "value",
          bits: "31:0",
          desc: "Placeholder 32-bit field for extracted signal"
        }
      ]
    },
    {
      name: "txt_buffer_ram_port_b_address_i",
      desc: "Auto-extracted signal port_b_address_i from txt_buffer_ram.vhd",
      swaccess: "rw",
      hwaccess: "hrw",
      fields: [
        {
          name: "value",
          bits: "31:0",
          desc: "Placeholder 32-bit field for extracted signal"
        }
      ]
    },
    {
      name: "txt_buffer_ram_port_b_data_out_i",
      desc: "Auto-extracted signal port_b_data_out_i from txt_buffer_ram.vhd",
      swaccess: "rw",
      hwaccess: "hrw",
      fields: [
        {
          name: "value",
          bits: "31:0",
          desc: "Placeholder 32-bit field for extracted signal"
        }
      ]
    },
    {
      name: "txt_buffer_ram_tst_ena",
      desc: "Auto-extracted signal tst_ena from txt_buffer_ram.vhd",
      swaccess: "rw",
      hwaccess: "hrw",
      fields: [
        {
          name: "value",
          bits: "31:0",
          desc: "Placeholder 32-bit field for extracted signal"
        }
      ]
    },
    {
      name: "txt_buffer_ram_tst_addr",
      desc: "Auto-extracted signal tst_addr from txt_buffer_ram.vhd",
      swaccess: "rw",
      hwaccess: "hrw",
      fields: [
        {
          name: "value",
          bits: "31:0",
          desc: "Placeholder 32-bit field for extracted signal"
        }
      ]
    },
    {
      name: "access_signaler_be_active",
      desc: "Auto-extracted signal be_active from access_signaler.vhd",
      swaccess: "rw",
      hwaccess: "hrw",
      fields: [
        {
          name: "value",
          bits: "31:0",
          desc: "Placeholder 32-bit field for extracted signal"
        }
      ]
    },
    {
      name: "access_signaler_access_in",
      desc: "Auto-extracted signal access_in from access_signaler.vhd",
      swaccess: "rw",
      hwaccess: "hrw",
      fields: [
        {
          name: "value",
          bits: "31:0",
          desc: "Placeholder 32-bit field for extracted signal"
        }
      ]
    },
    {
      name: "access_signaler_access_active",
      desc: "Auto-extracted signal access_active from access_signaler.vhd",
      swaccess: "rw",
      hwaccess: "hrw",
      fields: [
        {
          name: "value",
          bits: "31:0",
          desc: "Placeholder 32-bit field for extracted signal"
        }
      ]
    },
    {
      name: "access_signaler_access_active_reg",
      desc: "Auto-extracted signal access_active_reg from access_signaler.vhd",
      swaccess: "rw",
      hwaccess: "hrw",
      fields: [
        {
          name: "value",
          bits: "31:0",
          desc: "Placeholder 32-bit field for extracted signal"
        }
      ]
    },
    {
      name: "address_decoder_addr_dec_i",
      desc: "Auto-extracted signal addr_dec_i from address_decoder.vhd",
      swaccess: "rw",
      hwaccess: "hrw",
      fields: [
        {
          name: "value",
          bits: "31:0",
          desc: "Placeholder 32-bit field for extracted signal"
        }
      ]
    },
    {
      name: "address_decoder_addr_dec_enabled_i",
      desc: "Auto-extracted signal addr_dec_enabled_i from address_decoder.vhd",
      swaccess: "rw",
      hwaccess: "hrw",
      fields: [
        {
          name: "value",
          bits: "31:0",
          desc: "Placeholder 32-bit field for extracted signal"
        }
      ]
    }
  ]
}