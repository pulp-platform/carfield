// Copyright 2020 ETH Zurich and University of Bologna.
// Licensed under the Apache License, Version 2.0, see LICENSE for details.
// SPDX-License-Identifier: Apache-2.0
//
// Author: Michael Rogenmoser <michaero@iis.ee.ethz.ch>

{
  name: "ECC_manager",
  cip_id: "36",
  version: "0.0.0", // null, commit 5616a36
  clocking: [
    {clock: "clk_i", reset: "rst_ni", idle: "idle_o", primary: true}
  ],
  bus_interfaces: [
    { protocol: "tlul",
      direction: "device"
    }
  ],

  regwidth: "32",
  registers: [
    { name: "mismatch_count",
      desc: "Correctable mismatches caught by ecc on access",
      swaccess: "rw0c",
      hwaccess: "hrw",
      resval: "0",
      fields: [
        { bits: "31:0",
          name: "correctable_mismatches",
          desc: "Correctable mismatches caught by ecc on access"
        }
      ]
    },
    { name: "scrub_interval",
      desc: "Interval between scrubs",
      swaccess: "rw",
      hwaccess: "hro",
      fields: [
        { bits: "31:0"
          name: "scrub_interval"
          desc: "Interval between scrubs"
        }
      ]
    },
    { name: "scrub_fix_count",
      desc: "Correctable mismatches caught by ecc on scrub",
      swaccess: "rw0c",
      hwaccess: "hrw",
      resval: "0",
      fields: [
        { bits: "31:0",
          name: "correctable_mismatches",
          desc: "Correctable mismatches caught by ecc on scrub"
        }
      ]
    },
    { name: "scrub_uncorrectable_count",
      desc: "Uncorrectable mismatches caught by ecc on scrub",
      swaccess: "rw0c",
      hwaccess: "hrw",
      resval: "0",
      fields: [
        { bits: "31:0",
          name: "uncorrectable_mismatches",
          desc: "Uncorrectable mismatches caught by ecc on scrub"
        }
      ]
    },
    { name: "write_mask_data_n",
      desc: "Testing: Inverted write mask for data bits",
      swaccess: "rw",
      hwaccess: "hro",
      resval: "0",
      fields: [
        { bits: "31:0",
          name: "write_mask_data_n",
          desc: "Testing: Inverted write mask for data bits"
        }
      ]
    },
    { name: "write_mask_ecc_n",
      desc: "Testing: Inverted write mask for ECC bits",
      swaccess: "rw",
      hwaccess: "hro",
      resval: "0",
      fields: [
        { bits: "6:0",
          name: "write_mask_ecc_n",
          desc: "Testing: Inverted write mask for ECC bits"
        }
      ]
    }
  ],
}