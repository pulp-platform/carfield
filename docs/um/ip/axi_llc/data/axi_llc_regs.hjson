// Copyright 2018-2021 ETH Zurich and University of Bologna.
// Solderpad Hardware License, Version 0.51, see LICENSE for details.
// SPDX-License-Identifier: SHL-0.51
//
// Authors: 
// Nicole Narr <narrn@ethz.ch>
// Christopher Reinwardt <creinwar@ethz.ch>



{
  name: "axi_llc",
  clock_primary: "clk_i",
  bus_interfaces: [
    { protocol: "reg_iface", direction: "device" }
  ],
  regwidth: 32,
  registers: [

    { name: "CFG_SPM_LOW",
      desc: "SPM Configuration (lower 32 bit)",
      swaccess: "rw",
      hwaccess: "hrw",
      fields: [
        {bits: "31:0", resval: 0, name: "low", desc: "lower 32 bit"}
      ]
    },
    { name: "CFG_SPM_HIGH",
      desc: "SPM Configuration (upper 32 bit)",
      swaccess: "rw",
      hwaccess: "hrw",
      fields: [
        {bits: "31:0", name: "high", desc: "upper 32 bit"}
      ]
    },
    { name: "CFG_FLUSH_LOW",
      desc: "Flush Configuration (lower 32 bit)",
      swaccess: "rw",
      hwaccess: "hrw",
      fields: [
        {bits: "31:0", name: "low", desc: "lower 32 bit"}
      ]
    },
    { name: "CFG_FLUSH_HIGH",
      desc: "Flush Configuration (upper 32 bit)",
      swaccess: "rw",
      hwaccess: "hrw",
      fields: [
        {bits: "31:0", name: "high", desc: "upper 32 bit"}
      ]
    },
    { name: "COMMIT_CFG",
      desc: "Commit the configuration",
      swaccess: "rw1s",
      hwaccess: "hrw",
      fields: [
        {bits: "0", name: "commit", desc: "commit configuration"}
      ]
    },
    {skipto: "0x18"}
    { name: "FLUSHED_LOW",
      desc: "Flushed Flag (lower 32 bit)",
      swaccess: "ro",
      hwaccess: "hrw",
      fields: [
        {bits: "31:0", name: "low", desc: "lower 32 bit"}
      ]
    },
    { name: "FLUSHED_HIGH",
      desc: "Flushed Flag (upper 32 bit)",
      swaccess: "ro",
      hwaccess: "hrw",
      fields: [
        {bits: "31:0", name: "high", desc: "upper 32 bit"}
      ]
    },
    { name: "BIST_OUT_LOW",
      desc: "Tag Storage BIST Result (lower 32 bit)",
      swaccess: "ro",
      hwaccess: "hwo",
      fields: [
        {bits: "31:0", name: "low", desc: "lower 32 bit"}
      ]
    },
    { name: "BIST_OUT_HIGH",
      desc: "Tag Storage BIST Result (upper 32 bit)",
      swaccess: "ro",
      hwaccess: "hwo",
      fields: [
        {bits: "31:0", name: "high", desc: "upper 32 bit"}
      ]
    },
    { name: "SET_ASSO_LOW",
      desc: "Instantiated Set-Associativity (lower 32 bit)",
      swaccess: "ro",
      hwaccess: "hwo",
      fields: [
        {bits: "31:0", name: "low", desc: "lower 32 bit"}
      ]
    },
    { name: "SET_ASSO_HIGH",
      desc: "Instantiated Set-Associativity (upper 32 bit)",
      swaccess: "ro",
      hwaccess: "hwo",
      fields: [
        {bits: "31:0", name: "high", desc: "upper 32 bit"}
      ]
    },
    { name: "NUM_LINES_LOW",
      desc: "Instantiated Number of Cache-Lines (lower 32 bit)",
      swaccess: "ro",
      hwaccess: "hwo",
      fields: [
        {bits: "31:0", name: "low", desc: "lower 32 bit"}
      ]
    },
    { name: "NUM_LINES_HIGH",
      desc: "Instantiated Number of Cache-Lines (upper 32 bit)",
      swaccess: "ro",
      hwaccess: "hwo",
      fields: [
        {bits: "31:0", name: "high", desc: "upper 32 bit"}
      ]
    },
    { name: "NUM_BLOCKS_LOW",
      desc: "Instantiated Number of Blocks (lower 32 bit)",
      swaccess: "ro",
      hwaccess: "hwo",
      fields: [
        {bits: "31:0", name: "low", desc: "lower 32 bit"}
      ]
    },
    { name: "NUM_BLOCKS_HIGH",
      desc: "Instantiated Number of Blocks (upper 32 bit)",
      swaccess: "ro",
      hwaccess: "hwo",
      fields: [
        {bits: "31:0", name: "high", desc: "upper 32 bit"}
      ]
    },
    { name: "VERSION_LOW",
      desc: "AXI LLC Version (lower 32 bit)",
      swaccess: "ro",
      hwaccess: "hwo",
      fields: [
        {bits: "31:0", name: "low", desc: "lower 32 bit"}
      ]
    },
    { name: "VERSION_HIGH",
      desc: "AXI LLC Version (upper 32 bit)",
      swaccess: "ro",
      hwaccess: "hwo",
      fields: [
        {bits: "31:0", name: "high", desc: "upper 32 bit"}
      ]
    },
    { name: "BIST_STATUS",
      desc: "Status register of the BIST",
      swaccess: "ro",
      hwaccess: "hwo",
      fields: [
        {bits: "0:0", name: "done", desc: "BIST successfully completed"}
      ]
    }
  ]
}