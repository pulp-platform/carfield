
// Copyright 2022 ETH Zurich and University of Bologna.
// Copyright and related rights are licensed under the Solderpad Hardware
// License, Version 0.51 (the "License"); you may not use this file except in
// compliance with the License.  You may obtain a copy of the License at
// http://solderpad.org/licenses/SHL-0.51. Unless required by applicable law
// or agreed to in writing, software, hardware and materials distributed under
// this License is distributed on an "AS IS" BASIS, WITHOUT WARRANTIES OR
// CONDITIONS OF ANY KIND, either express or implied. See the License for the
// specific language governing permissions and limitations under the License.

// SPDX-License-Identifier: Apache-2.0

// CLIC virtual supervisor configuration register
{
  name: "CLICVS",
  cip_id: "36",
  version: "3.0.0", //3.0.0-for-carfield
  clocking: [
    {clock: "clk_i", reset: "rst_ni", idle: "idle_o", primary: true}
  ],
  bus_interfaces: [
    { protocol: "tlul", direction: "device" }
  ],

  regwidth: "32",
  registers: [
    { name: "vsprio",
      desc: "CLIC virtual supervisor priority",
      swaccess: "rw",
      hwaccess: "hro",
      fields: [
        { bits: "24", name: "prio3", desc: "VS3 priority" },
        { bits: "16", name: "prio2", desc: "VS2 priority" },
        { bits:  "8", name: "prio1", desc: "VS1 priority" },
        { bits:  "0", name: "prio0", desc: "VS0 priority" },
      ],
    }
  ]
}
