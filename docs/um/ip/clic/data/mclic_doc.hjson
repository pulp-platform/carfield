
// Copyright 2022 ETH Zurich and University of Bologna.
// Copyright and related rights are licensed under the Solderpad Hardware
// License, Version 0.51 (the "License"); you may not use this file except in
// compliance with the License.  You may obtain a copy of the License at
// http://solderpad.org/licenses/SHL-0.51. Unless required by applicable law
// or agreed to in writing, software, hardware and materials distributed under
// this License is distributed on an "AS IS" BASIS, WITHOUT WARRANTIES OR
// CONDITIONS OF ANY KIND, either express or implied. See the License for the
// specific language governing permissions and limitations under the License.

// SPDX-License-Identifier: Apache-2.0

# CLIC m-mode registers
{
  name: "MCLIC",
  cip_id: "36",
  version: "3.0.0", //3.0.0-for-carfield
  clocking: [
    {clock: "clk_i", reset: "rst_ni", idle: "idle_o", primary: true}
  ],
  bus_interfaces: [
    { protocol: "tlul", direction: "device" }
  ],

  regwidth: "32",
  registers: [
    { name: "MCLICCFG",
      desc: "CLIC configuration",
      swaccess: "rw",
      hwaccess: "hro",
      fields: [
        { bits: "31:28", name: "reserved", desc: "reserved", swaccess: "ro", hwaccess: "none" },  # workaround for full 32-bit access
        { bits: "27:24", name: "unlbits", desc: "number of privilege mode bits in user mode" },
        //{ bits: "23:20", name: "reserved" },
        { bits: "19:16", name: "snlbits", desc: "number of privilege mode bits in supervisor mode" },
        //{ bits: "15:6", name: "reserved" },
        { bits: "5:4", name: "nmbits", desc: "number of privilege mode bits" },
        { bits: "3:0", name: "mnlbits", desc: "number of interrupt level bits in machine mode" },
      ],
    },
    { name: "CLICMNXTICONF",
      desc: "CLIC enable mnxti irq forwarding logic",
      swaccess: "rw",
      hwaccess: "hro",
      fields: [
        { bits: "0" }
      ],
    },
  ]
}
