// Copyright 2018-2021 ETH Zurich and University of Bologna.
// Solderpad Hardware License, Version 0.51, see LICENSE for details.
// SPDX-License-Identifier: SHL-0.51
// Licensed under Solderpad Hardware License, Version 0.51, see LICENSE for details.
//
// Author: Florent Rotenberg <florent.rotenberg@greenwaves-technologies.com>
# APB Advanced timer register
{
  name: "apb_adv_timer"
  one_paragraph_desc: '''
  ADV_ TIMER component manages the following features:
  - 4 advanced timers with 4 output signal channels each. Provides PWM generation functionality
  - multiple trigger input sources:
     - output signal channels of all timers
     - 32 GPIOs
     - reference clock at 32kHz
     - FLL clock
  - configurable input trigger modes
  - configurable prescaler for each timer
  - configurable counting mode for each timer
  - configurable channel threshold action for each timer
  - 4 configurable output events
  - configurable clock gating of each timer
  '''
  cip_id:  "36",
  version: "1.0.4"
  clocking: [
    {clock: "clk_i", reset: "rst_ni", primary: true}
  ],
  bus_interfaces: [
    { protocol: "tlul", direction: "device" }
  ],
  regwidth: "32"
  registers: [
    { name: "T0_CMD"
      desc: "ADV_TIMER0 command register."
      swaccess: "wo"
      hwaccess: "hwo"
      fields: [
        { bits: "0"
          name: "START"
          resval: 0x0
          desc: "ADV_TIMER0 start command bitfield."
        }
        { bits: "1"
          name: "STOP"
          resval: 0x0
          desc: "ADV_TIMER0 stop command bitfield."
        }
        { bits: "2"
          name: "UPDATE"
          resval: 0x0
          desc: "ADV_TIMER0 update command bitfield."
        }
        { bits: "3"
          name: "RESET"
          resval: 0x0
          desc: "ADV_TIMER0 reset command bitfield."
        }
        { bits: "4"
          name: "ARM"
          resval: 0x0
          desc: "ADV_TIMER0 arm command bitfield."
        }
        { bits: "31:5"
          name: "RFU"
          resval: 0x0
          desc: "?"
        }
      ]
    }
    { name: "T0_CONFIG"
      desc: "ADV_TIMER0 configuration register."
      swaccess: "rw"
      hwaccess: "hrw"
      fields: [
        { bits: "7:0"
          name: "INSEL"
          resval: 0x0
          desc: '''ADV_TIMER0 input source configuration bitfield:
                - 0-31: GPIO[0] to GPIO[31]
                - 32-35: Channel 0 to 3 of ADV_TIMER0
                - 36-39: Channel 0 to 3 of ADV_TIMER1
                - 40-43: Channel 0 to 3 of ADV_TIMER2
                - 44-47: Channel 0 to 3 of ADV_TIMER3
                '''
        }
        { bits: "10:8"
          name: "MODE"
	  swaccess: "rw"
          hwaccess: "hrw"
          resval: 0x0
          desc: '''ADV_TIMER0 trigger mode configuration bitfield:
                - 3'h0: trigger event at each clock cycle.
                - 3'h1: trigger event if input source is 0
                - 3'h2: trigger event if input source is 1
                - 3'h3: trigger event on input source rising edge
                - 3'h4: trigger event on input source falling edge
                - 3'h5: trigger event on input source falling or rising edge
                - 3'h6: trigger event on input source rising edge when armed
                - 3'h7: trigger event on input source falling edge when armed
                '''
        }
        { bits: "11"
          name: "CLKSEL"
          resval: 0x0
          desc: '''ADV_TIMER0 clock source configuration bitfield:
                - 1'b0: FLL
                - 1'b1: reference clock at 32kHz
                '''
        }
        { bits: "12"
          name: "UPDOWNSEL"
          resval: 0x1
          desc: '''ADV_TIMER0 center-aligned mode configuration bitfield:
                - 1'b0: The counter counts up and down alternatively.
                - 1'b1: The counter counts up and resets to 0 when reach threshold.	
                '''
        }
        { bits: "23:16"
          name: "PRESC"
          resval: 0x0
          desc: "ADV_TIMER0 prescaler value configuration bitfield."
        }
      ]
    }
    { name: "T0_THRESHOLD"
      desc: "ADV_TIMER0 threshold configuration register."
      swaccess: "rw"
      hwaccess: "hrw"
      fields: [
        { bits: "15:0"
          name: "TH_LO"
          resval: 0x0
          desc: "ADV_TIMER0 threshold low part configuration bitfield. It defines start counter value."
        }
	{ bits: "31:16"
          name: "TH_HI"
          resval: 0x0
          desc: "ADV_TIMER0 threshold high part configuration bitfield. It defines end counter value."
        }
      ]
    }
    { name: "T0_TH_CHANNEL0"
      desc: "ADV_TIMER0 channel 0 threshold configuration register."
      swaccess: "rw"
      hwaccess: "hrw"
      fields: [
        { bits: "15:0"
          name: "TH"
          resval: 0x0
          desc: "ADV_TIMER0 channel 0 threshold configuration bitfield."
        }
	{ bits: "18:16"
          name: "MODE"
          resval: 0x0
          desc: '''ADV_TIMER0 channel 0 threshold match action on channel output signal configuration bitfield:
                - 3'h0: set.
                - 3'h1: toggle then next threshold match action is clear.
                - 3'h2: set then next threshold match action is clear.
                - 3'h3: toggle.
                - 3'h4: clear.
                - 3'h5: toggle then next threshold match action is set.
                - 3'h6: clear then next threshold match action is set.
	        '''
        }
      ]
    }
    { name: "T0_TH_CHANNEL1"
      desc: "ADV_TIMER0 channel 1 threshold configuration register."
      swaccess: "rw"
      hwaccess: "hrw"
      fields: [
        { bits: "15:0"
          name: "TH"
          resval: 0x0
          desc: "ADV_TIMER0 channel 1 threshold configuration bitfield."
        }
        { bits: "18:16"
          name: "MODE"
          resval: 0x0
          desc:	'''ADV_TIMER0 channel 1 threshold match action on channel output signal configuration bitfield:
                - 3'h0: set.
                - 3'h1: toggle then next threshold match action is clear.
                - 3'h2: set then next threshold match action is clear.
                - 3'h3: toggle.
                - 3'h4: clear.
                - 3'h5: toggle then next threshold match action is set.
                - 3'h6: clear then next threshold match action is set.
                '''
        }
      ]
    }
    { name: "T0_TH_CHANNEL2"
      desc: "ADV_TIMER0 channel 2 threshold configuration register."
      swaccess: "rw"
      hwaccess: "hrw"
      fields: [
        { bits: "15:0"
          name: "TH"
          resval: 0x0
          desc: "ADV_TIMER0 channel 2 threshold configuration bitfield."
        }
        { bits: "18:16"
          name: "MODE"
          resval: 0x0
          desc:	'''ADV_TIMER0 channel 2 threshold match action on channel output signal configuration bitfield:
                - 3'h0: set.
                - 3'h1: toggle then next threshold match action is clear.
                - 3'h2: set then next threshold match action is clear.
                - 3'h3: toggle.
                - 3'h4: clear.
                - 3'h5: toggle then next threshold match action is set.
                - 3'h6: clear then next threshold match action is set.
                '''
        }
      ]
    }
    { name: "T0_TH_CHANNEL3"
      desc: "ADV_TIMER0 channel 3 threshold configuration register."
      swaccess: "rw"
      hwaccess: "hrw"
      fields: [
        { bits: "15:0"
          name: "TH"
          resval: 0x0
          desc: "ADV_TIMER0 channel 3 threshold configuration bitfield."
        }
        { bits: "18:16"
          name: "MODE"
          resval: 0x0
          desc:	'''ADV_TIMER0 channel 3 threshold match action on channel output signal configuration bitfield:
                - 3'h0: set.
                - 3'h1: toggle then next threshold match action is clear.
                - 3'h2: set then next threshold match action is clear.
                - 3'h3: toggle.
                - 3'h4: clear.
                - 3'h5: toggle then next threshold match action is set.
                - 3'h6: clear then next threshold match action is set.
                '''
        }
      ]
    }
    { name: "T0_COUNTER"
      desc: "ADV_TIMER0 counter register."
      swaccess: "ro"
      hwaccess: "hwo"
      fields: [
        { bits: "15:0"
          name: "COUNTER"
          resval: 0x0
          desc: "ADV_TIMER0 counter value."
        }
      ]
    }
    { name: "T1_CMD"
      desc: "ADV_TIMER1 command register."
      swaccess: "wo"
      hwaccess: "hwo"
      fields: [
        { bits: "0"
          name: "START"
          resval: 0x0
          desc: "ADV_TIMER1 start command bitfield."
        }
        { bits: "1"
          name: "STOP"
          resval: 0x0
          desc: "ADV_TIMER1 stop command bitfield."
        }
        { bits: "2"
          name: "UPDATE"
          resval: 0x0
          desc: "ADV_TIMER1 update command bitfield."
        }
        { bits: "3"
          name: "RESET"
          resval: 0x0
          desc: "ADV_TIMER1 reset command bitfield."
        }
        { bits: "4"
          name: "ARM"
          resval: 0x0
          desc: "ADV_TIMER1 arm command bitfield."
        }
      ]
    }
    { name: "T1_CONFIG"
      desc: "ADV_TIMER1 configuration register."
      swaccess: "rw"
      hwaccess: "hrw"
      fields: [
        { bits: "7:0"
          name: "INSEL"
          resval: 0x0
          desc: '''ADV_TIMER1 input source configuration bitfield:
                - 0-31: GPIO[0] to GPIO[31]
                - 32-35: Channel 0 to 3 of ADV_TIMER0
                - 36-39: Channel 0 to 3 of ADV_TIMER1
                - 40-43: Channel 0 to 3 of ADV_TIMER2
                - 44-47: Channel 0 to 3 of ADV_TIMER3
                '''
        }
        { bits: "10:8"
          name: "MODE"
          swaccess: "rw"
          hwaccess: "hrw"
          resval: 0x0
          desc: '''ADV_TIMER1 trigger mode configuration bitfield:
                - 3'h0: trigger event at each clock cycle.
                - 3'h1: trigger event if input source is 0
                - 3'h2: trigger event if input source is 1
                - 3'h3: trigger event on input source rising edge
                - 3'h4: trigger event on input source falling edge
                - 3'h5: trigger event on input source falling or rising edge
                - 3'h6: trigger event on input source rising edge when armed
                - 3'h7: trigger event on input source falling edge when armed
                '''
        }
        { bits: "11"
          name: "CLKSEL"
          resval: 0x0
          desc: '''ADV_TIMER1 clock source configuration bitfield:
                - 1'b0: FLL
                - 1'b1: reference clock at 32kHz
                '''
        }
	{ bits: "12"
          name: "UPDOWNSEL"
          resval: 0x1
          desc: '''ADV_TIMER1 center-aligned mode configuration bitfield:
                - 1'b0: The counter counts up and down alternatively.
                - 1'b1: The counter counts up and resets to 0 when reach threshold.
                '''
        }
        { bits: "23:16"
          name: "PRESC"
          resval: 0x0
          desc: "ADV_TIMER1 prescaler value configuration bitfield."
        }
      ]
    }
    { name: "T1_THRESHOLD"
      desc: "ADV_TIMER1 threshold configuration register."
      swaccess: "rw"
      hwaccess: "hrw"
      fields: [
        { bits: "15:0"
          name: "TH_LO"
          resval: 0x0
          desc: "ADV_TIMER1 threshold low part configuration bitfield. It defines start counter value."
        }
        { bits: "31:16"
          name: "TH_HI"
          resval: 0x0
          desc: "ADV_TIMER1 threshold high part configuration bitfield. It defines end counter value."
        }
      ]
    }
    { name: "T1_TH_CHANNEL0"
      desc: "ADV_TIMER1 channel 0 threshold configuration register."
      swaccess: "rw"
      hwaccess: "hrw"
      fields: [
        { bits: "15:0"
          name: "TH"
          resval: 0x0
          desc: "ADV_TIMER1 channel 0 threshold configuration bitfield."
        }
        { bits: "18:16"
          name: "MODE"
          resval: 0x0
          desc: '''ADV_TIMER1 channel 0 threshold match action on channel output signal configuration bitfield:
                - 3'h0: set.
                - 3'h1: toggle then next threshold match action is clear.
                - 3'h2: set then next threshold match action is clear.
                - 3'h3: toggle.
                - 3'h4: clear.
                - 3'h5: toggle then next threshold match action is set.
                - 3'h6: clear then next threshold match action is set.
                '''
        }
      ]
    }
    { name: "T1_TH_CHANNEL1"
      desc: "ADV_TIMER1 channel 1 threshold configuration register."
      swaccess: "rw"
      hwaccess: "hrw"
      fields: [
        { bits: "15:0"
          name: "TH"
          resval: 0x0
          desc: "ADV_TIMER1 channel 1 threshold configuration bitfield."
        }
        { bits: "18:16"
          name: "MODE"
          resval: 0x0
          desc: '''ADV_TIMER1 channel 1 threshold match action on channel output signal configuration bitfield:
                - 3'h0: set.
                - 3'h1: toggle then next threshold match action is clear.
                - 3'h2: set then next threshold match action is clear.
                - 3'h3: toggle.
                - 3'h4: clear.
                - 3'h5: toggle then next threshold match action is set.
                - 3'h6: clear then next threshold match action is set.
                '''
        }
      ]
    }
    { name: "T1_TH_CHANNEL2"
      desc: "ADV_TIMER1 channel 2 threshold configuration register."
      swaccess: "rw"
      hwaccess: "hrw"
      fields: [
        { bits: "15:0"
          name: "TH"
          resval: 0x0
          desc: "ADV_TIMER1 channel 2 threshold configuration bitfield."
        }
        { bits: "18:16"
          name: "MODE"
          resval: 0x0
          desc: '''ADV_TIMER1 channel 2 threshold match action on channel output signal configuration bitfield:
                - 3'h0: set.
                - 3'h1: toggle then next threshold match action is clear.
                - 3'h2: set then next threshold match action is clear.
                - 3'h3: toggle.
                - 3'h4: clear.
                - 3'h5: toggle then next threshold match action is set.
                - 3'h6: clear then next threshold match action is set.
                '''
        }
      ]
    }
    { name: "T1_TH_CHANNEL3"
      desc: "ADV_TIMER1 channel 3 threshold configuration register."
      swaccess: "rw"
      hwaccess: "hrw"
      fields: [
        { bits: "15:0"
          name: "TH"
          resval: 0x0
          desc: "ADV_TIMER1 channel 3 threshold configuration bitfield."
        }
        { bits: "18:16"
          name: "MODE"
          resval: 0x0
          desc: '''ADV_TIMER1 channel 3 threshold match action on channel output signal configuration bitfield:
                - 3'h0: set.
                - 3'h1: toggle then next threshold match action is clear.
                - 3'h2: set then next threshold match action is clear.
                - 3'h3: toggle.
                - 3'h4: clear.
                - 3'h5: toggle then next threshold match action is set.
                - 3'h6: clear then next threshold match action is set.
                '''
        }
      ]
    }
    { name: "T1_COUNTER"
      desc: "ADV_TIMER1 counter register."
      swaccess: "ro"
      hwaccess: "hwo"
      fields: [
        { bits: "15:0"
          name: "COUNTER"
          resval: 0x0
          desc: "ADV_TIMER1 counter value."
        }
      ]
    }
    { name: "T2_CMD"
      desc: "ADV_TIMER2 command register."
      swaccess: "wo"
      hwaccess: "hwo"
      fields: [
        { bits: "0"
          name: "START"
          resval: 0x0
          desc: "ADV_TIMER2 start command bitfield."
        }
        { bits: "1"
          name: "STOP"
          resval: 0x0
          desc: "ADV_TIMER2 stop command bitfield."
        }
        { bits: "2"
          name: "UPDATE"
          resval: 0x0
          desc: "ADV_TIMER2 update command bitfield."
        }
        { bits: "3"
          name: "RESET"
          resval: 0x0
          desc: "ADV_TIMER2 reset command bitfield."
        }
        { bits: "4"
          name: "ARM"
          resval: 0x0
          desc: "ADV_TIMER2 arm command bitfield."
        }
      ]
    }
    { name: "T2_CONFIG"
      desc: "ADV_TIMER2 configuration register."
      swaccess: "rw"
      hwaccess: "hrw"
      fields: [
        { bits: "7:0"
          name: "INSEL"
          resval: 0x0
          desc: '''ADV_TIMER2 input source configuration bitfield:
                - 0-31: GPIO[0] to GPIO[31]
                - 32-35: Channel 0 to 3 of ADV_TIMER0
                - 36-39: Channel 0 to 3 of ADV_TIMER1
                - 40-43: Channel 0 to 3 of ADV_TIMER2
                - 44-47: Channel 0 to 3 of ADV_TIMER3
                '''
        }
        { bits: "10:8"
          name: "MODE"
          swaccess: "rw"
          hwaccess: "hrw"
          resval: 0x0
          desc: '''ADV_TIMER2 trigger mode configuration bitfield:
                - 3'h0: trigger event at each clock cycle.
                - 3'h1: trigger event if input source is 0
                - 3'h2: trigger event if input source is 1
                - 3'h3: trigger event on input source rising edge
                - 3'h4: trigger event on input source falling edge
                - 3'h5: trigger event on input source falling or rising edge
                - 3'h6: trigger event on input source rising edge when armed
                - 3'h7: trigger event on input source falling edge when armed
                '''
        }
        { bits: "11"
          name: "CLKSEL"
          resval: 0x0
          desc: '''ADV_TIMER2 clock source configuration bitfield:
                - 1'b0: FLL
                - 1'b1: reference clock at 32kHz
                '''
        }
        { bits: "12"
          name: "UPDOWNSEL"
          resval: 0x1
          desc: '''ADV_TIMER2 center-aligned mode configuration bitfield:
                - 1'b0: The counter counts up and down alternatively.
                - 1'b1: The counter counts up and resets to 0 when reach threshold.
                '''
        }
        { bits: "23:16"
          name: "PRESC"
          resval: 0x0
          desc: "ADV_TIMER2 prescaler value configuration bitfield."
        }
      ]
    }
    { name: "T2_THRESHOLD"
      desc: "ADV_TIMER2 threshold configuration register."
      swaccess: "rw"
      hwaccess: "hrw"
      fields: [
        { bits: "15:0"
          name: "TH_LO"
          resval: 0x0
          desc: "ADV_TIMER2 threshold low part configuration bitfield. It defines start counter value."
        }
        { bits: "31:16"
          name: "TH_HI"
          resval: 0x0
          desc: "ADV_TIMER2 threshold high part configuration bitfield. It defines end counter value."
        }
      ]
    }
    { name: "T2_TH_CHANNEL0"
      desc: "ADV_TIMER2 channel 0 threshold configuration register."
      swaccess: "rw"
      hwaccess: "hrw"
      fields: [
        { bits: "15:0"
          name: "TH"
          resval: 0x0
          desc: "ADV_TIMER2 channel 0 threshold configuration bitfield."
        }
        { bits: "18:16"
          name: "MODE"
          resval: 0x0
          desc: '''ADV_TIMER2 channel 0 threshold match action on channel output signal configuration bitfield:
                - 3'h0: set.
                - 3'h1: toggle then next threshold match action is clear.
                - 3'h2: set then next threshold match action is clear.
                - 3'h3: toggle.
                - 3'h4: clear.
                - 3'h5: toggle then next threshold match action is set.
                - 3'h6: clear then next threshold match action is set.
                '''
        }
      ]
    }
    { name: "T2_TH_CHANNEL1"
      desc: "ADV_TIMER2 channel 1 threshold configuration register."
      swaccess: "rw"
      hwaccess: "hrw"
      fields: [
        { bits: "15:0"
          name: "TH"
          resval: 0x0
          desc: "ADV_TIMER2 channel 1 threshold configuration bitfield."
        }
        { bits: "18:16"
          name: "MODE"
          resval: 0x0
          desc: '''ADV_TIMER2 channel 1 threshold match action on channel output signal configuration bitfield:
                - 3'h0: set.
                - 3'h1: toggle then next threshold match action is clear.
                - 3'h2: set then next threshold match action is clear.
                - 3'h3: toggle.
                - 3'h4: clear.
                - 3'h5: toggle then next threshold match action is set.
                - 3'h6: clear then next threshold match action is set.
                '''
        }
      ]
    }
    { name: "T2_TH_CHANNEL2"
      desc: "ADV_TIMER2 channel 2 threshold configuration register."
      swaccess: "rw"
      hwaccess: "hrw"
      fields: [
        { bits: "15:0"
          name: "TH"
          resval: 0x0
          desc: "ADV_TIMER2 channel 2 threshold configuration bitfield."
        }
        { bits: "18:16"
          name: "MODE"
          resval: 0x0
          desc: '''ADV_TIMER2 channel 2 threshold match action on channel output signal configuration bitfield:
                - 3'h0: set.
                - 3'h1: toggle then next threshold match action is clear.
                - 3'h2: set then next threshold match action is clear.
                - 3'h3: toggle.
                - 3'h4: clear.
                - 3'h5: toggle then next threshold match action is set.
                - 3'h6: clear then next threshold match action is set.
                '''
        }
      ]
    }
    { name: "T2_TH_CHANNEL3"
      desc: "ADV_TIMER2 channel 3 threshold configuration register."
      swaccess: "rw"
      hwaccess: "hrw"
      fields: [
        { bits: "15:0"
          name: "TH"
          resval: 0x0
          desc: "ADV_TIMER2 channel 3 threshold configuration bitfield."
        }
        { bits: "18:16"
          name: "MODE"
          resval: 0x0
          desc: '''ADV_TIMER2 channel 3 threshold match action on channel output signal configuration bitfield:
                - 3'h0: set.
                - 3'h1: toggle then next threshold match action is clear.
                - 3'h2: set then next threshold match action is clear.
                - 3'h3: toggle.
                - 3'h4: clear.
                - 3'h5: toggle then next threshold match action is set.
                - 3'h6: clear then next threshold match action is set.
                '''
        }
      ]
    }
    { name: "T2_COUNTER"
      desc: "ADV_TIMER2 counter register."
      swaccess: "ro"
      hwaccess: "hwo"
      fields: [
        { bits: "15:0"
          name: "COUNTER"
          resval: 0x0
          desc: "ADV_TIMER2 counter value."
        }
      ]
    }
    { name: "T3_CMD"
      desc: "ADV_TIMER3 command register."
      swaccess: "wo"
      hwaccess: "hwo"
      fields: [
        { bits: "0"
          name: "START"
          resval: 0x0
          desc: "ADV_TIMER3 start command bitfield."
        }
        { bits: "1"
          name: "STOP"
          resval: 0x0
          desc: "ADV_TIMER3 stop command bitfield."
        }
        { bits: "2"
          name: "UPDATE"
          resval: 0x0
          desc: "ADV_TIMER3 update command bitfield."
        }
        { bits: "3"
          name: "RESET"
          resval: 0x0
          desc: "ADV_TIMER3 reset command bitfield."
        }
        { bits: "4"
          name: "ARM"
          resval: 0x0
          desc: "ADV_TIMER3 arm command bitfield."
        }
      ]
    }
    { name: "T3_CONFIG"
      desc: "ADV_TIMER3 configuration register."
      swaccess: "rw"
      hwaccess: "hrw"
      fields: [
        { bits: "7:0"
          name: "INSEL"
          resval: 0x0
          desc: '''ADV_TIMER3 input source configuration bitfield:
                - 0-31: GPIO[0] to GPIO[31]
                - 32-35: Channel 0 to 3 of ADV_TIMER0
                - 36-39: Channel 0 to 3 of ADV_TIMER1
                - 40-43: Channel 0 to 3 of ADV_TIMER2
                - 44-47: Channel 0 to 3 of ADV_TIMER3
                '''
        }
        { bits: "10:8"
          name: "MODE"
          swaccess: "rw"
          hwaccess: "hrw"
          resval: 0x0
          desc: '''ADV_TIMER3 trigger mode configuration bitfield:
                - 3'h0: trigger event at each clock cycle.
                - 3'h1: trigger event if input source is 0
                - 3'h2: trigger event if input source is 1
                - 3'h3: trigger event on input source rising edge
                - 3'h4: trigger event on input source falling edge
                - 3'h5: trigger event on input source falling or rising edge
                - 3'h6: trigger event on input source rising edge when armed
                - 3'h7: trigger event on input source falling edge when armed
                '''
        }
        { bits: "11"
          name: "CLKSEL"
          resval: 0x0
          desc: '''ADV_TIMER3 clock source configuration bitfield:
                - 1'b0: FLL
                - 1'b1: reference clock at 32kHz
                '''
        }
        { bits: "12"
          name: "UPDOWNSEL"
          resval: 0x1
          desc: '''ADV_TIMER3 center-aligned mode configuration bitfield:
                - 1'b0: The counter counts up and down alternatively.
                - 1'b1: The counter counts up and resets to 0 when reach threshold.
                '''
        }
        { bits: "23:16"
          name: "PRESC"
          resval: 0x0
          desc: "ADV_TIMER3 prescaler value configuration bitfield."
        }
      ]
    }
    { name: "T3_THRESHOLD"
      desc: "ADV_TIMER3 threshold configuration register."
      swaccess: "rw"
      hwaccess: "hrw"
      fields: [
        { bits: "15:0"
          name: "TH_LO"
          resval: 0x0
          desc: "ADV_TIMER3 threshold low part configuration bitfield. It defines start counter value."
        }
        { bits: "31:16"
          name: "TH_HI"
          resval: 0x0
          desc: "ADV_TIMER3 threshold high part configuration bitfield. It defines end counter value."
        }
      ]
    }
    { name: "T3_TH_CHANNEL0"
      desc: "ADV_TIMER3 channel 0 threshold configuration register."
      swaccess: "rw"
      hwaccess: "hrw"
      fields: [
        { bits: "15:0"
          name: "TH"
          resval: 0x0
          desc: "ADV_TIMER3 channel 0 threshold configuration bitfield."
        }
        { bits: "18:16"
          name: "MODE"
          resval: 0x0
          desc: '''ADV_TIMER3 channel 0 threshold match action on channel output signal configuration bitfield:
                - 3'h0: set.
                - 3'h1: toggle then next threshold match action is clear.
                - 3'h2: set then next threshold match action is clear.
                - 3'h3: toggle.
                - 3'h4: clear.
                - 3'h5: toggle then next threshold match action is set.
                - 3'h6: clear then next threshold match action is set.
                '''
        }
      ]
    }
    { name: "T3_TH_CHANNEL1"
      desc: "ADV_TIMER3 channel 1 threshold configuration register."
      swaccess: "rw"
      hwaccess: "hrw"
      fields: [
        { bits: "15:0"
          name: "TH"
          resval: 0x0
          desc: "ADV_TIMER3 channel 1 threshold configuration bitfield."
        }
        { bits: "18:16"
          name: "MODE"
          resval: 0x0
          desc: '''ADV_TIMER3 channel 1 threshold match action on channel output signal configuration bitfield:
                - 3'h0: set.
                - 3'h1: toggle then next threshold match action is clear.
                - 3'h2: set then next threshold match action is clear.
                - 3'h3: toggle.
                - 3'h4: clear.
                - 3'h5: toggle then next threshold match action is set.
                - 3'h6: clear then next threshold match action is set.
                '''
        }
      ]
    }
    { name: "T3_TH_CHANNEL2"
      desc: "ADV_TIMER3 channel 2 threshold configuration register."
      swaccess: "rw"
      hwaccess: "hrw"
      fields: [
        { bits: "15:0"
          name: "TH"
          resval: 0x0
          desc: "ADV_TIMER3 channel 2 threshold configuration bitfield."
        }
        { bits: "18:16"
          name: "MODE"
          resval: 0x0
          desc: '''ADV_TIMER3 channel 2 threshold match action on channel output signal configuration bitfield:
                - 3'h0: set.
                - 3'h1: toggle then next threshold match action is clear.
                - 3'h2: set then next threshold match action is clear.
                - 3'h3: toggle.
                - 3'h4: clear.
                - 3'h5: toggle then next threshold match action is set.
                - 3'h6: clear then next threshold match action is set.
                '''
        }
      ]
    }
    { name: "T3_TH_CHANNEL3"
      desc: "ADV_TIMER3 channel 3 threshold configuration register."
      swaccess: "rw"
      hwaccess: "hrw"
      fields: [
        { bits: "15:0"
          name: "TH"
          resval: 0x0
          desc: "ADV_TIMER3 channel 3 threshold configuration bitfield."
        }
        { bits: "18:16"
          name: "MODE"
          resval: 0x0
          desc: '''ADV_TIMER3 channel 3 threshold match action on channel output signal configuration bitfield:
                - 3'h0: set.
                - 3'h1: toggle then next threshold match action is clear.
                - 3'h2: set then next threshold match action is clear.
                - 3'h3: toggle.
                - 3'h4: clear.
                - 3'h5: toggle then next threshold match action is set.
                - 3'h6: clear then next threshold match action is set.
                '''
        }
      ]
    }
    { name: "T3_COUNTER"
      desc: "ADV_TIMER3 counter register."
      swaccess: "ro"
      hwaccess: "hwo"
      fields: [
        { bits: "15:0"
          name: "COUNTER"
          resval: 0x0
          desc: "ADV_TIMER3 counter value."
        }
      ]
    }
    { name: "EVENT_CFG"
      desc: "ADV_TIMERS events configuration register."
      swaccess: "rw"
      hwaccess: "hrw"
      fields: [
        { bits: "3:0"
          name: "SEL0"
          resval: 0x0
          desc: '''ADV_TIMER output event 0 source configuration bitfiled:
                - 4'h0: ADV_TIMER0 channel 0.
                - 4'h1: ADV_TIMER0 channel 1.
                - 4'h2: ADV_TIMER0 channel 2.
                - 4'h3: ADV_TIMER0 channel 3.
                - 4'h4: ADV_TIMER1 channel 0.
                - 4'h5: ADV_TIMER1 channel 1.
                - 4'h6: ADV_TIMER1 channel 2.
                - 4'h7: ADV_TIMER1 channel 3.
                - 4'h8: ADV_TIMER2 channel 0.
                - 4'h9: ADV_TIMER2 channel 1.
                - 4'hA: ADV_TIMER2 channel 2.
                - 4'hB: ADV_TIMER2 channel 3.
                - 4'hC: ADV_TIMER3 channel 0.
                - 4'hD: ADV_TIMER3 channel 1.
                - 4'hE: ADV_TIMER3 channel 2.
                - 4'hF: ADV_TIMER3 channel 3.
                '''
        }
	{ bits: "7:4"
          name: "SEL1"
          resval: 0x0
          desc: '''ADV_TIMER output event 1 source configuration bitfiled:
                - 4'h0: ADV_TIMER0 channel 0.
                - 4'h1: ADV_TIMER0 channel 1.
                - 4'h2: ADV_TIMER0 channel 2.
                - 4'h3: ADV_TIMER0 channel 3.
                - 4'h4: ADV_TIMER1 channel 0.
                - 4'h5: ADV_TIMER1 channel 1.
                - 4'h6: ADV_TIMER1 channel 2.
                - 4'h7: ADV_TIMER1 channel 3.
                - 4'h8: ADV_TIMER2 channel 0.
                - 4'h9: ADV_TIMER2 channel 1.
                - 4'hA: ADV_TIMER2 channel 2.
                - 4'hB: ADV_TIMER2 channel 3.
                - 4'hC: ADV_TIMER3 channel 0.
                - 4'hD: ADV_TIMER3 channel 1.
                - 4'hE: ADV_TIMER3 channel 2.
                - 4'hF: ADV_TIMER3 channel 3.
                '''
        }
	{ bits: "11:8"
          name: "SEL2"
          resval: 0x0
          desc: '''ADV_TIMER output event 2 source configuration bitfiled:
                - 4'h0: ADV_TIMER0 channel 0.
                - 4'h1: ADV_TIMER0 channel 1.
                - 4'h2: ADV_TIMER0 channel 2.
                - 4'h3: ADV_TIMER0 channel 3.
                - 4'h4: ADV_TIMER1 channel 0.
                - 4'h5: ADV_TIMER1 channel 1.
                - 4'h6: ADV_TIMER1 channel 2.
                - 4'h7: ADV_TIMER1 channel 3.
                - 4'h8: ADV_TIMER2 channel 0.
                - 4'h9: ADV_TIMER2 channel 1.
                - 4'hA: ADV_TIMER2 channel 2.
                - 4'hB: ADV_TIMER2 channel 3.
                - 4'hC: ADV_TIMER3 channel 0.
                - 4'hD: ADV_TIMER3 channel 1.
                - 4'hE: ADV_TIMER3 channel 2.
                - 4'hF: ADV_TIMER3 channel 3.
                '''
        }
	{ bits: "15:12"
          name: "SEL3"
          resval: 0x0
          desc: '''ADV_TIMER output event 3 source configuration bitfiled:
                - 4'h0: ADV_TIMER0 channel 0.
                - 4'h1: ADV_TIMER0 channel 1.
                - 4'h2: ADV_TIMER0 channel 2.
                - 4'h3: ADV_TIMER0 channel 3.
                - 4'h4: ADV_TIMER1 channel 0.
                - 4'h5: ADV_TIMER1 channel 1.
                - 4'h6: ADV_TIMER1 channel 2.
                - 4'h7: ADV_TIMER1 channel 3.
                - 4'h8: ADV_TIMER2 channel 0.
                - 4'h9: ADV_TIMER2 channel 1.
                - 4'hA: ADV_TIMER2 channel 2.
                - 4'hB: ADV_TIMER2 channel 3.
                - 4'hC: ADV_TIMER3 channel 0.
                - 4'hD: ADV_TIMER3 channel 1.
                - 4'hE: ADV_TIMER3 channel 2.
                - 4'hF: ADV_TIMER3 channel 3.
                '''
        }
        { bits: "19:16"
          name: "ENA"
          resval: 0x0
          desc: "ADV_TIMER output event enable configuration bitfield. ENA[i]=1 enables output event i generation."
        }
      ]
    }
    { name: "CG"
      desc: "ADV_TIMERS channels clock gating configuration register."
      swaccess: "rw"
      hwaccess: "hrw"
      fields: [
        { bits: "3:0"
          name: "ENA"
          resval: 0x0
          desc: '''ADV_TIMER clock gating configuration bitfield.
                - ENA[i]=0: clock gate ADV_TIMERi.
                - ENA[i]=1: enable ADV_TIMERi.
                '''
        }
      ]
    }
  ]
}
