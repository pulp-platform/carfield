// Copyright 2020 ETH Zurich and University of Bologna.
// Licensed under the Apache License, Version 2.0, see LICENSE for details.
// SPDX-License-Identifier: Apache-2.0
//
// Author: Florian Zaruba <zarubaf@iis.ee.ethz.ch>

{
  name: "CLINT",
  cip_id: "2",
  version:            "0.2.0",
  clocking: [
    {clock: "clk_i", reset: "rst_ni", idle: "idle_o", primary: true}
  ],
  bus_interfaces: [
    { protocol: "tlul", direction: "device" }
  ],
  regwidth: "32",
  param_list: [
    { name: "NumCores",
      desc: "Number of cores",
      type: "int",
      default: "2",
      local: "true"
    }
  ],
  registers: [
    { multireg: {
        name: "MSIP",
        desc: "Machine Software Interrupt Pending",
        count: "2",   // Number of cores
        cname: "MSIP",
        swaccess: "rw",
        hwaccess: "hro",
        fields: [
          { bits: "0", name: "P", desc: "Machine Software Interrupt Pending" },
          { bits: "31:1", name: "RSVD", desc: "Reserved", resval: "0", swaccess: "ro", hwaccess: "none" }
        ]
      }
    },
    { skipto: "0x4000" },

    // Core 0 MTIMECMP Registers
    { name: "MTIMECMP_LOW0",
      desc: "Machine Timer Compare for Core 0",
      swaccess: "rw",
      hwaccess: "hro",
      fields: [
        { bits: "31:0", name: "MTIMECMP_LOW", desc: "Machine Time Compare (Low) Core 0" }
      ]
    },
    { name: "MTIMECMP_HIGH0",
      desc: "Machine Timer Compare for Core 0",
      swaccess: "rw",
      hwaccess: "hro",
      fields: [
        { bits: "31:0", name: "MTIMECMP_HIGH", desc: "Machine Time Compare (High) Core 0" }
      ]
    },

    // Core 1 MTIMECMP Registers
    { name: "MTIMECMP_LOW1",
      desc: "Machine Timer Compare for Core 1",
      swaccess: "rw",
      hwaccess: "hro",
      fields: [
        { bits: "31:0", name: "MTIMECMP_LOW", desc: "Machine Time Compare (Low) Core 1" }
      ]
    },
    { name: "MTIMECMP_HIGH1",
      desc: "Machine Timer Compare for Core 1",
      swaccess: "rw",
      hwaccess: "hro",
      fields: [
        { bits: "31:0", name: "MTIMECMP_HIGH", desc: "Machine Time Compare (High) Core 1" }
      ]
    },

    { skipto: "0xBFF8" },

    { name: "MTIME_LOW",
      desc: "Timer Register Low",
      swaccess: "rw",
      hwaccess: "hrw",
      fields: [
        { bits: "31:0", name: "MTIME_LOW", desc: "Machine Time (Low)" }
      ]
    },
    { name: "MTIME_HIGH",
      desc: "Timer Register High",
      swaccess: "rw",
      hwaccess: "hrw",
      fields: [
        { bits: "31:0", name: "MTIME_HIGH", desc: "Machine Time (High)" }
      ]
    }
  ]
}